* SKY130 transistor-level simulation
.lib /foss/pdks/sky130A/libs.tech/ngspice/sky130.lib.spice tt
.include netlist/silicluster_jonah_2cap_dac.spice
VDD vdd 0 1.8
VHI refh 0 .9
VLO refl 0 .2
RHI refh hi 500
RLO refl lo 500
CHI hi 0 5p
CLO lo 0 5p
ROUT out pad 500
COUT pad 0 5p
RLOAD pad 0 10Meg
XDUT 0 vdd h l s hi lo out silicluster_jonah_2cap_dac
VFORCE XDUT.HOLD 0 .2
VH h 0 0
VL l 0 0
VS s 0 0
.control
set wr_vecnames
set wr_singlescale
dc VFORCE .15 1.0 .005
wrdata verification/buffer_dc.txt v(out) v(pad) v(XDUT.BIAS) v(XDUT.TAIL)
quit
.endc
.end
