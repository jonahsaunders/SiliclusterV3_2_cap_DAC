* Suarez DAC extracted-layout qualification
.include sim/models/sky130_tt.spice
.include netlist/silicluster_jonah_2cap_dac.rc.spice
.temp 27
VDD vdd 0 1.8
VHI refh 0 .9
VLO refl 0 .2
RHI refh hi 500
RLO refl lo 500
CHI hi 0 5p
CLO lo 0 5p
ROUT out pad 500
COUT pad 0 5p
RLOAD pad 0 10Meg
XDUT 0 vdd h l s hi lo out silicluster_jonah_2cap_dac_pex
.options method=trap reltol=1e-5 abstol=1e-13 vntol=1e-7
VH h 0 0
VL l 0 0
VS s 0 0
VFORCE XDUT.HOLD 0 .55 AC 1
.control
set num_threads=1
set wr_vecnames
set wr_singlescale
noise v(pad) VFORCE dec 100 .1 100Meg
wrdata verification/signoff/noise_tt_27.txt onoise_total inoise_total
setplot noise1
wrdata verification/signoff/noise_tt_27_spectrum.txt onoise_spectrum
quit
.endc
.end
