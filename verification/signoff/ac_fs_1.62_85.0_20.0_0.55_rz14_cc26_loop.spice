* PEX produced on Fri Oct  2 10:10:21 PM CEST 2026 using /foss/tools/sak/sak-pex.sh with m=3 and s=1 (extresist threshold=1000 mOhm, minres=1000 mOhm, mindelay=0 ps)
* NGSPICE file created from silicluster_jonah_2cap_dac_pex.ext - technology: sky130A

.subckt silicluster_jonah_2cap_dac_pex VGND VDPWR charge_high charge_low share vref_high  vref_low vout
X0 VDPWR.t13 charge_high.t1 H_BAR.t1 VDPWR.t12 sky130_fd_pr__pfet_01v8 ad=0.58 pd=4.58 as=0.58 ps=4.58 w=2 l=0.15
X1 VGND.t53 charge_low.t2 L_BAR.t0 VGND.t52 sky130_fd_pr__nfet_01v8 ad=0.29 pd=2.58 as=0.29 ps=2.58 w=1 l=0.15
X2 SAMPLE.t5 charge_low.t0 vref_low.t1 VGND.t54 sky130_fd_pr__nfet_01v8 ad=0.29 pd=2.58 as=0.29 ps=2.58 w=1 l=0.15
X3 HOLD VGND.t6 sky130_fd_pr__cap_mim_m3_1 l=14 w=14
X4 HOLD VGND.t4 sky130_fd_pr__cap_mim_m3_1 l=14 w=14
X5 SAMPLE VGND.t4 sky130_fd_pr__cap_mim_m3_1 l=14 w=14
X6 SAMPLE VGND.t6 sky130_fd_pr__cap_mim_m3_1 l=14 w=14
X7 SAMPLE VGND.t8 sky130_fd_pr__cap_mim_m3_1 l=14 w=14
X8 SAMPLE VGND.t2 sky130_fd_pr__cap_mim_m3_1 l=14 w=14
X9 VGND.t49 charge_high.t2 H_BAR.t0 VGND.t48 sky130_fd_pr__nfet_01v8 ad=0.29 pd=2.58 as=0.29 ps=2.58 w=1 l=0.15
X10 SAMPLE.t4 charge_high.t0 vref_high.t1 VGND.t50 sky130_fd_pr__nfet_01v8 ad=0.29 pd=2.58 as=0.29 ps=2.58 w=1 l=0.15
X11 HOLD VGND.t2 sky130_fd_pr__cap_mim_m3_1 l=14 w=14
X12 VGND.t11 MIRROR.t3 AMP.t1 VGND.t10 sky130_fd_pr__nfet_01v8 ad=1.16 pd=8.58 as=1.16 ps=8.58 w=4 l=2
X13 HOLD VGND.t2 sky130_fd_pr__cap_mim_m3_1 l=14 w=14
X14 TAIL.t2 FBX MIRROR.t2 VDPWR.t14 sky130_fd_pr__pfet_01v8_lvt ad=1.16 pd=8.58 as=1.16 ps=8.58 w=4 l=1
X15 SAMPLE VGND.t2 sky130_fd_pr__cap_mim_m3_1 l=14 w=14
X16 HOLD VGND.t6 sky130_fd_pr__cap_mim_m3_1 l=14 w=14
X17 SAMPLE VGND.t2 sky130_fd_pr__cap_mim_m3_1 l=14 w=14
X18 HOLD VGND.t4 sky130_fd_pr__cap_mim_m3_1 l=14 w=14
X19 HOLD.t0 S_BAR.t2 SAMPLE.t2 VDPWR.t2 sky130_fd_pr__pfet_01v8_lvt ad=0.58 pd=4.58 as=0.58 ps=4.58 w=2 l=0.35
X20 HOLD VGND.t8 sky130_fd_pr__cap_mim_m3_1 l=14 w=14
X21 SAMPLE VGND.t4 sky130_fd_pr__cap_mim_m3_1 l=14 w=14
X22 VDPWR.t6 BIAS.t4 TAIL.t0 VDPWR.t5 sky130_fd_pr__pfet_01v8 ad=1.16 pd=8.58 as=1.16 ps=8.58 w=4 l=2
X23 HOLD VGND.t6 sky130_fd_pr__cap_mim_m3_1 l=14 w=14
X24 HOLD VGND.t6 sky130_fd_pr__cap_mim_m3_1 l=14 w=14
X25 SAMPLE VGND.t8 sky130_fd_pr__cap_mim_m3_1 l=14 w=14
X26 HOLD VGND.t8 sky130_fd_pr__cap_mim_m3_1 l=14 w=14
X27 SAMPLE.t0 L_BAR.t2 vref_low.t0 VDPWR.t0 sky130_fd_pr__pfet_01v8_lvt ad=0.58 pd=4.58 as=0.58 ps=4.58 w=2 l=0.35
X28 VDPWR.t8 BIAS.t1 BIAS.t2 VDPWR.t7 sky130_fd_pr__pfet_01v8 ad=1.16 pd=8.58 as=1.16 ps=8.58 w=4 l=2
X29 AMP.t2 COMP VGND.t44 sky130_fd_pr__res_xhigh_po_0p35 l=14
X30 SAMPLE VGND.t4 sky130_fd_pr__cap_mim_m3_1 l=14 w=14
X31 RBMID VGND.t43 VGND.t42 sky130_fd_pr__res_xhigh_po_0p35 l=30
X32 SAMPLE.t1 H_BAR.t2 vref_high.t0 VDPWR.t1 sky130_fd_pr__pfet_01v8_lvt ad=0.58 pd=4.58 as=0.58 ps=4.58 w=2 l=0.35
X33 BIAS.t0 RBMID VGND.t41 sky130_fd_pr__res_xhigh_po_0p35 l=30
X34 HOLD VGND.t4 sky130_fd_pr__cap_mim_m3_1 l=14 w=14
X35 SAMPLE VGND.t6 sky130_fd_pr__cap_mim_m3_1 l=14 w=14
X36 HOLD VGND.t4 sky130_fd_pr__cap_mim_m3_1 l=14 w=14
X37 VGND.t13 MIRROR.t0 MIRROR.t1 VGND.t12 sky130_fd_pr__nfet_01v8 ad=1.16 pd=8.58 as=1.16 ps=8.58 w=4 l=2
X38 VGND.t1 AMP.t3 vout.t0 VGND.t0 sky130_fd_pr__nfet_01v8 ad=5.8 pd=40.58 as=5.8 ps=40.58 w=20 l=1
X39 COMP vout.t2 sky130_fd_pr__cap_mim_m3_1 l=26 w=26
X40 HOLD VGND.t2 sky130_fd_pr__cap_mim_m3_1 l=14 w=14
X41 TAIL.t1 HOLD.t2 AMP.t0 VDPWR.t9 sky130_fd_pr__pfet_01v8_lvt ad=1.16 pd=8.58 as=1.16 ps=8.58 w=4 l=1
X42 SAMPLE VGND.t6 sky130_fd_pr__cap_mim_m3_1 l=14 w=14
X43 SAMPLE VGND.t2 sky130_fd_pr__cap_mim_m3_1 l=14 w=14
X44 HOLD VGND.t2 sky130_fd_pr__cap_mim_m3_1 l=14 w=14
X45 HOLD VGND.t8 sky130_fd_pr__cap_mim_m3_1 l=14 w=14
X46 SAMPLE VGND.t8 sky130_fd_pr__cap_mim_m3_1 l=14 w=14
X47 SAMPLE VGND.t6 sky130_fd_pr__cap_mim_m3_1 l=14 w=14
X48 HOLD VGND.t8 sky130_fd_pr__cap_mim_m3_1 l=14 w=14
X49 VDPWR.t11 share.t1 S_BAR.t1 VDPWR.t10 sky130_fd_pr__pfet_01v8 ad=0.58 pd=4.58 as=0.58 ps=4.58 w=2 l=0.15
X50 VDPWR.t4 BIAS.t3 vout.t1 VDPWR.t3 sky130_fd_pr__pfet_01v8 ad=6.96 pd=48.58 as=6.96 ps=48.58 w=24 l=2
X51 VDPWR.t16 charge_low.t1 L_BAR.t1 VDPWR.t15 sky130_fd_pr__pfet_01v8 ad=0.58 pd=4.58 as=0.58 ps=4.58 w=2 l=0.15
X52 VGND.t46 share.t2 S_BAR.t0 VGND.t45 sky130_fd_pr__nfet_01v8 ad=0.29 pd=2.58 as=0.29 ps=2.58 w=1 l=0.15
X53 HOLD.t1 share.t0 SAMPLE.t3 VGND.t47 sky130_fd_pr__nfet_01v8 ad=0.29 pd=2.58 as=0.29 ps=2.58 w=1 l=0.15
X54 SAMPLE VGND.t8 sky130_fd_pr__cap_mim_m3_1 l=14 w=14
X55 SAMPLE VGND.t4 sky130_fd_pr__cap_mim_m3_1 l=14 w=14
C0 AMP SAMPLE 0.90636f
C1 vout vref_high 1.07787f
C2 BIAS TAIL 1.14771f
C3 MIRROR L_BAR 0.30518f
C4 charge_high vref_low 0.15129f
C5 VDPWR AMP 4.0862f
C6 charge_high share 0.31637f
C7 BIAS vout 5.64417f
C8 BIAS vref_high 0.67981f
C9 charge_high SAMPLE 0.74138f
C10 VDPWR charge_high 5.16047f
C11 L_BAR AMP 0.32572f
C12 RBMID TAIL 0.28059f
C13 HOLD TAIL 0.94092f
C14 RBMID vout 6.33235f
C15 L_BAR charge_high 0.24326f
C16 vref_low S_BAR 0.2005f
C17 RBMID vref_high 0.08621f
C18 HOLD vout 1.06652f
C19 share S_BAR 1.73094f
C20 HOLD vref_high 1.34791f
C21 BIAS RBMID 27.2898f
C22 S_BAR SAMPLE 0.90771f
C23 BIAS HOLD 17.648f
C24 VDPWR S_BAR 1.47885f
C25 vref_low share 0.31581f
C26 vref_low SAMPLE 15.6351f
C27 VDPWR vref_low 0.85134f
C28 share SAMPLE 1.11898f
C29 VDPWR share 1.70165f
C30 L_BAR S_BAR 14.0415f
C31 VDPWR SAMPLE 2.96114f
C32 HOLD RBMID 0.82066f
C33 charge_low TAIL 0.09588f
C34 H_BAR TAIL 0.26273f
C35 COMP TAIL 0.39101f
C36 L_BAR vref_low 0.56894f
C37 charge_low vout 0.34499f
C38 H_BAR vout 0.60159f
C39 charge_low vref_high 0.31955f
C40 vout COMP 88.206f
C41 H_BAR vref_high 0.55001f
C42 L_BAR share 0.18608f
C43 vref_high COMP 0.28757f
C44 MIRROR TAIL 14.7801f
C45 L_BAR SAMPLE 0.94254f
C46 BIAS charge_low 0.13759f
C47 BIAS H_BAR 0.44326f
C48 MIRROR vout 1.41213f
C49 BIAS COMP 0.61847f
C50 VDPWR L_BAR 1.47678f
C51 MIRROR vref_high 0.30573f
C52 BIAS MIRROR 0.32391f
C53 TAIL AMP 14.5619f
C54 vout AMP 5.59254f
C55 vref_high AMP 0.36079f
C56 charge_low RBMID 0.1591f
C57 H_BAR RBMID 0.0546f
C58 RBMID COMP 0.34126f
C59 charge_high TAIL 0.09588f
C60 HOLD charge_low 0.54663f
C61 BIAS AMP 0.81912f
C62 HOLD H_BAR 0.30556f
C63 HOLD COMP 0.82333f
C64 charge_high vout 0.34848f
C65 charge_high vref_high 0.71753f
C66 MIRROR RBMID 14.1735f
C67 MIRROR HOLD 0.36443f
C68 BIAS charge_high 0.11255f
C69 RBMID AMP 12.299f
C70 TAIL S_BAR 0.22804f
C71 HOLD AMP 1.5858f
C72 vout S_BAR 0.61292f
C73 vref_high S_BAR 14.0727f
C74 charge_high RBMID 0.09755f
C75 HOLD charge_high 0.13989f
C76 vref_low TAIL 0.22855f
C77 H_BAR charge_low 0.76108f
C78 charge_low COMP 0.12909f
C79 BIAS S_BAR 0.33222f
C80 H_BAR COMP 0.25511f
C81 share TAIL 0.09588f
C82 vref_low vout 1.80542f
C83 vref_low vref_high 15.0081f
C84 TAIL SAMPLE 0.2295f
C85 vout share 0.80799f
C86 MIRROR charge_low 0.09581f
C87 MIRROR H_BAR 0.35143f
C88 share vref_high 0.30393f
C89 MIRROR COMP 0.41072f
C90 VDPWR TAIL 4.03493f
C91 vout SAMPLE 1.30602f
C92 BIAS vref_low 1.01769f
C93 vref_high SAMPLE 1.77477f
C94 VDPWR vout 11.147f
C95 BIAS share 0.13127f
C96 VDPWR vref_high 0.86976f
C97 BIAS SAMPLE 1.22764f
C98 RBMID S_BAR 0.04231f
C99 BIAS VDPWR 7.37419f
C100 charge_low AMP 0.12231f
C101 L_BAR TAIL 0.22804f
C102 H_BAR AMP 0.33432f
C103 HOLD S_BAR 0.68861f
C104 COMP AMP 27.1138f
C105 L_BAR vout 0.5336f
C106 L_BAR vref_high 0.20135f
C107 RBMID vref_low 0.16036f
C108 MIRROR AMP 1.49262f
C109 charge_high charge_low 2.94145f
C110 H_BAR charge_high 1.84677f
C111 RBMID share 0.1328f
C112 charge_high COMP 0.12909f
C113 HOLD vref_low 0.81247f
C114 BIAS L_BAR 0.32031f
C115 HOLD share 0.81245f
C116 RBMID SAMPLE 0.62895f
C117 MIRROR charge_high 0.09581f
C118 VDPWR RBMID 2.26323f
C119 HOLD SAMPLE 7.73697f
C120 VDPWR HOLD 2.42188f
C121 L_BAR RBMID 0.04221f
C122 charge_high AMP 0.10627f
C123 charge_low S_BAR 0.251f
C124 H_BAR S_BAR 0.2516f
C125 HOLD L_BAR 0.35767f
C126 COMP S_BAR 0.25324f
C127 MIRROR S_BAR 0.30551f
C128 charge_low vref_low 0.78075f
C129 H_BAR vref_low 0.19024f
C130 vref_low COMP 0.28961f
C131 charge_low share 2.94123f
C132 H_BAR share 3.98516f
C133 share COMP 0.1946f
C134 charge_low SAMPLE 0.93022f
C135 H_BAR SAMPLE 0.87168f
C136 MIRROR vref_low 0.30593f
C137 COMP SAMPLE 1.30705f
C138 VDPWR charge_low 1.8988f
C139 VDPWR H_BAR 3.22917f
C140 VDPWR COMP 4.44695f
C141 MIRROR share 0.09581f
C142 AMP S_BAR 0.33692f
C143 MIRROR SAMPLE 0.31918f
C144 VDPWR MIRROR 1.83089f
C145 charge_high S_BAR 0.23469f
C146 vref_low AMP 0.66207f
C147 L_BAR charge_low 1.60091f
C148 H_BAR L_BAR 14.0577f
C149 vout TAIL 1.39738f
C150 L_BAR COMP 0.26653f
C151 share AMP 0.15041f
C152 vref_high TAIL 0.22843f
C153 vout VGND 93.83439f
C154 vref_low VGND 26.63809f
C155 vref_high VGND 26.42393f
C156 share VGND 8.25166f
C157 charge_low VGND 8.01006f
C158 charge_high VGND 7.94353f
C159 VDPWR VGND 79.15408f
C160 RBMID VGND 29.4595f
C161 MIRROR VGND 17.83198f
C162 AMP VGND 33.7281f
C163 TAIL VGND 13.95962f
C164 S_BAR VGND 12.03089f
C165 L_BAR VGND 11.18795f
C166 H_BAR VGND 32.63869f
C167 BIAS VGND 33.68814f
C168 BIAS.n0 VGND 10.5804f
C169 BIAS.n1 VGND 0.02353f
C170 BIAS.t2 VGND 0.69362f
C171 BIAS.n2 VGND 0.1789f
C172 BIAS.n3 VGND 0.01351f
C173 BIAS.n4 VGND 2.57341f
C174 BIAS.n5 VGND 0.04187f
C175 BIAS.n6 VGND 2.06517f
C176 BIAS.n7 VGND 0.01351f
C177 BIAS.n8 VGND 0.54529f
C178 BIAS.n9 VGND 0.04187f
C179 BIAS.n10 VGND 0.87405f
C180 BIAS.n11 VGND 0.01351f
C181 BIAS.n12 VGND 0.54529f
C182 BIAS.n13 VGND 0.04187f
C183 BIAS.n14 VGND 0.87405f
C184 BIAS.t0 VGND 0.15835f
C185 BIAS.n15 VGND 13.2621f
C186 BIAS.n16 VGND 19.6523f
C187 BIAS.n17 VGND 1.12324f
C188 H_BAR.n0 VGND 0.03622f
C189 H_BAR.t1 VGND 0.13574f
C190 H_BAR.n1 VGND 0.01174f
C191 H_BAR.t0 VGND 0.0592f
C192 H_BAR.n2 VGND 0.06392f
C193 H_BAR.n3 VGND 0.02024f
C194 H_BAR.n4 VGND 0.83991f
C195 H_BAR.n5 VGND 0.98939f
C196 H_BAR.n6 VGND 0.03566f
C197 L_BAR.n0 VGND 26.298f
C198 L_BAR.n1 VGND 0.04505f
C199 L_BAR.t1 VGND 0.15779f
C200 L_BAR.n2 VGND 0.0146f
C201 L_BAR.t0 VGND 0.06563f
C202 L_BAR.n3 VGND 0.07952f
C203 L_BAR.n4 VGND 0.02518f
C204 L_BAR.n5 VGND 1.11062f
C205 L_BAR.n6 VGND 1.29659f
C206 L_BAR.n7 VGND 0.04436f
C207 S_BAR.n0 VGND 25.7085f
C208 S_BAR.n1 VGND 0.04486f
C209 S_BAR.t1 VGND 0.15981f
C210 S_BAR.n2 VGND 0.01454f
C211 S_BAR.t0 VGND 0.068f
C212 S_BAR.n3 VGND 0.07917f
C213 S_BAR.n4 VGND 0.02507f
C214 S_BAR.n5 VGND 1.17154f
C215 S_BAR.n6 VGND 1.35671f
C216 S_BAR.n7 VGND 0.04416f
C217 SAMPLE.n0 VGND 0.08301f
C218 SAMPLE.n1 VGND 0.09161f
C219 SAMPLE.n2 VGND 0.35289f
C220 SAMPLE.t3 VGND 0.06207f
C221 SAMPLE.t2 VGND 0.13643f
C222 SAMPLE.n7 VGND 0.04028f
C223 SAMPLE.n8 VGND 0.11028f
C224 SAMPLE.n9 VGND 0.07881f
C225 SAMPLE.n10 VGND 0.11965f
C226 SAMPLE.n11 VGND 0.12835f
C227 SAMPLE.n12 VGND 0.08977f
C228 SAMPLE.n13 VGND 0.05677f
C229 SAMPLE.n14 VGND 0.09288f
C230 SAMPLE.n15 VGND 0.12835f
C231 SAMPLE.n16 VGND 0.08977f
C232 SAMPLE.n17 VGND 0.05677f
C233 SAMPLE.n18 VGND 0.06116f
C234 SAMPLE.n19 VGND 0.11028f
C235 SAMPLE.n20 VGND 0.07881f
C236 SAMPLE.n21 VGND 0.07582f
C237 SAMPLE.n22 VGND 0.06812f
C238 SAMPLE.n23 VGND 0.08293f
C239 SAMPLE.t4 VGND 0.05648f
C240 SAMPLE.n27 VGND 0.02341f
C241 SAMPLE.t1 VGND 0.1105f
C242 SAMPLE.n30 VGND 0.02745f
C243 SAMPLE.t5 VGND 0.05846f
C244 SAMPLE.n34 VGND 0.02341f
C245 SAMPLE.t0 VGND 0.13702f
C246 SAMPLE.n37 VGND 0.02745f
C247 SAMPLE.n38 VGND 0.02341f
C248 HOLD.n0 VGND 0.37372f
C249 HOLD.t1 VGND 0.06206f
C250 HOLD.n6 VGND 0.05276f
C251 HOLD.t0 VGND 0.13638f
C252 HOLD.n9 VGND 0.02887f
C253 HOLD.n10 VGND 0.12538f
C254 HOLD.n11 VGND 0.0875f
C255 HOLD.n12 VGND 0.10969f
C256 HOLD.n13 VGND 0.10771f
C257 HOLD.n14 VGND 0.068f
C258 HOLD.n15 VGND 0.07692f
C259 HOLD.n16 VGND 0.08217f
C260 HOLD.n17 VGND 0.10771f
C261 HOLD.n18 VGND 0.068f
C262 HOLD.n19 VGND 0.07692f
C263 HOLD.n20 VGND 0.04749f
C264 HOLD.n21 VGND 0.12538f
C265 HOLD.n22 VGND 0.0875f
C266 HOLD.n23 VGND 0.06479f
C267 HOLD.n24 VGND 0.06956f
C268 HOLD.n25 VGND 0.12088f
C269 HOLD.n26 VGND 0.02498f
C270 TAIL.n0 VGND 2.52157f
C271 TAIL.n1 VGND 0.01207f
C272 TAIL.t2 VGND 0.60132f
C273 TAIL.n2 VGND 0.03843f
C274 TAIL.t0 VGND 0.73087f
C275 TAIL.n3 VGND 0.2922f
C276 TAIL.n4 VGND 0.01207f
C277 TAIL.n5 VGND 2.02288f
C278 TAIL.n6 VGND 9.99226f
C279 TAIL.n7 VGND 13.6606f
C280 TAIL.n8 VGND 2.04639f
C281 TAIL.t1 VGND 0.1053f
C282 TAIL.n9 VGND 0.2922f
C283 TAIL.n10 VGND 0.03843f
C284 AMP.n1 VGND 0.02177f
C285 AMP.n2 VGND 1.35799f
C286 AMP.n3 VGND 0.02177f
C287 AMP.n4 VGND 1.57322f
C288 AMP.n5 VGND 0.02865f
C289 AMP.t1 VGND 0.89106f
C290 AMP.n6 VGND 0.22797f
C291 AMP.n8 VGND 1.57738f
C292 AMP.n9 VGND 7.57465f
C293 AMP.t2 VGND 0.19634f
C294 AMP.n10 VGND 16.2707f
C295 AMP.n11 VGND 27.1498f
C296 AMP.n12 VGND 4.87941f
C297 AMP.n13 VGND 1.60106f
C298 AMP.t0 VGND 0.08216f
C299 AMP.n14 VGND 0.22183f
C300 AMP.n15 VGND 0.02918f
C301 MIRROR.n0 VGND 18.5787f
C302 MIRROR.n2 VGND 0.01686f
C303 MIRROR.n3 VGND 0.68184f
C304 MIRROR.n4 VGND 0.05267f
C305 MIRROR.n5 VGND 1.57457f
C306 MIRROR.n6 VGND 0.01686f
C307 MIRROR.n7 VGND 0.68184f
C308 MIRROR.n8 VGND 0.05267f
C309 MIRROR.n9 VGND 1.22531f
C310 MIRROR.n10 VGND 0.02978f
C311 MIRROR.t1 VGND 0.89394f
C312 MIRROR.n11 VGND 0.23696f
C313 MIRROR.n13 VGND 1.54017f
C314 MIRROR.n14 VGND 1.56547f
C315 MIRROR.t2 VGND 0.32269f
C316 MIRROR.n15 VGND 0.23057f
C317 MIRROR.n16 VGND 0.03033f
C318 VGND.t4 VGND 0.4592p
C319 VGND.t6 VGND 0.45307p
C320 VGND.t53 VGND 0.03977f
C321 VGND.t13 VGND 0.81813f
C322 VGND.t11 VGND 0.81813f
C323 VGND.t1 VGND 1.90239f
C324 VGND.t46 VGND 0.04225f
C325 VGND.t49 VGND 0.03841f
C326 VDPWR.n0 VGND 1.34973f
C327 VDPWR.n1 VGND 1.29026f
C328 VDPWR.n2 VGND 32.8767f
C329 VDPWR.n3 VGND 1.00899f
C330 VDPWR.n4 VGND 0.98095f
C331 VDPWR.n5 VGND 2.51412f
C332 VDPWR.t13 VGND 0.07879f
C333 VDPWR.t12 VGND 0.04068f
C334 VDPWR.n10 VGND 0.1376f
C335 VDPWR.n17 VGND 0.09452f
C336 VDPWR.n28 VGND 0.1376f
C337 VDPWR.n49 VGND 0.09452f
C338 VDPWR.n52 VGND 0.10203f
C339 VDPWR.n53 VGND 1.18291f
C340 VDPWR.t16 VGND 0.07924f
C341 VDPWR.t15 VGND 0.04068f
C342 VDPWR.n58 VGND 0.1376f
C343 VDPWR.n65 VGND 0.09452f
C344 VDPWR.n76 VGND 0.1376f
C345 VDPWR.n97 VGND 0.09452f
C346 VDPWR.n100 VGND 0.10203f
C347 VDPWR.t11 VGND 0.08172f
C348 VDPWR.t10 VGND 0.04068f
C349 VDPWR.n105 VGND 0.1376f
C350 VDPWR.n112 VGND 0.09452f
C351 VDPWR.n123 VGND 0.1376f
C352 VDPWR.n144 VGND 0.09452f
C353 VDPWR.n147 VGND 0.10203f
C354 VDPWR.n153 VGND 0.04894f
C355 VDPWR.n154 VGND 0.08385f
C356 VDPWR.t1 VGND 0.02447f
C357 VDPWR.n162 VGND 0.04894f
C358 VDPWR.n163 VGND 0.03743f
C359 VDPWR.n167 VGND 0.08385f
C360 VDPWR.n175 VGND 0.07018f
C361 VDPWR.n181 VGND 0.04894f
C362 VDPWR.n188 VGND 0.03599f
C363 VDPWR.n194 VGND 0.07018f
C364 VDPWR.n198 VGND 0.10383f
C365 VDPWR.n199 VGND 0.66577f
C366 VDPWR.n205 VGND 0.04894f
C367 VDPWR.n206 VGND 0.08385f
C368 VDPWR.t0 VGND 0.02447f
C369 VDPWR.n214 VGND 0.04894f
C370 VDPWR.n215 VGND 0.03743f
C371 VDPWR.n219 VGND 0.08385f
C372 VDPWR.n227 VGND 0.07018f
C373 VDPWR.n233 VGND 0.04894f
C374 VDPWR.n240 VGND 0.03599f
C375 VDPWR.n246 VGND 0.07018f
C376 VDPWR.n250 VGND 0.10383f
C377 VDPWR.n251 VGND 0.66577f
C378 VDPWR.n257 VGND 0.04894f
C379 VDPWR.n258 VGND 0.08385f
C380 VDPWR.t2 VGND 0.02447f
C381 VDPWR.n266 VGND 0.04894f
C382 VDPWR.n267 VGND 0.03743f
C383 VDPWR.n271 VGND 0.08385f
C384 VDPWR.n279 VGND 0.07018f
C385 VDPWR.n285 VGND 0.04894f
C386 VDPWR.n292 VGND 0.03599f
C387 VDPWR.n298 VGND 0.07018f
C388 VDPWR.n302 VGND 0.10383f
C389 VDPWR.t8 VGND 0.73555f
C390 VDPWR.t7 VGND 0.06187f
C391 VDPWR.n307 VGND 0.12374f
C392 VDPWR.n312 VGND 0.12374f
C393 VDPWR.n316 VGND 0.19197f
C394 VDPWR.n348 VGND 0.1574f
C395 VDPWR.n354 VGND 0.0928f
C396 VDPWR.n355 VGND 0.12374f
C397 VDPWR.n397 VGND 0.19197f
C398 VDPWR.n398 VGND 0.1574f
C399 VDPWR.n399 VGND 0.12374f
C400 VDPWR.n405 VGND 0.0928f
C401 VDPWR.n408 VGND 0.10931f
C402 VDPWR.t6 VGND 0.73555f
C403 VDPWR.t5 VGND 0.06187f
C404 VDPWR.n413 VGND 0.12374f
C405 VDPWR.n418 VGND 0.12374f
C406 VDPWR.n422 VGND 0.19197f
C407 VDPWR.n454 VGND 0.1574f
C408 VDPWR.n460 VGND 0.0928f
C409 VDPWR.n461 VGND 0.12374f
C410 VDPWR.n503 VGND 0.19197f
C411 VDPWR.n504 VGND 0.1574f
C412 VDPWR.n505 VGND 0.12374f
C413 VDPWR.n511 VGND 0.0928f
C414 VDPWR.n514 VGND 0.10931f
C415 VDPWR.n518 VGND 0.1056f
C416 VDPWR.n521 VGND 0.06272f
C417 VDPWR.n528 VGND 0.06272f
C418 VDPWR.n532 VGND 0.04611f
C419 VDPWR.n536 VGND 0.06272f
C420 VDPWR.n540 VGND 0.06272f
C421 VDPWR.n544 VGND 0.06272f
C422 VDPWR.n548 VGND 0.1056f
C423 VDPWR.n561 VGND 0.08808f
C424 VDPWR.n567 VGND 0.06272f
C425 VDPWR.n573 VGND 0.06272f
C426 VDPWR.t9 VGND 0.03136f
C427 VDPWR.n579 VGND 0.04796f
C428 VDPWR.n585 VGND 0.06272f
C429 VDPWR.n592 VGND 0.06272f
C430 VDPWR.n599 VGND 0.08808f
C431 VDPWR.n605 VGND 0.11111f
C432 VDPWR.n609 VGND 0.1056f
C433 VDPWR.n612 VGND 0.06272f
C434 VDPWR.n619 VGND 0.06272f
C435 VDPWR.n623 VGND 0.04611f
C436 VDPWR.n627 VGND 0.06272f
C437 VDPWR.n631 VGND 0.06272f
C438 VDPWR.n635 VGND 0.06272f
C439 VDPWR.n639 VGND 0.1056f
C440 VDPWR.n652 VGND 0.08808f
C441 VDPWR.n658 VGND 0.06272f
C442 VDPWR.n664 VGND 0.06272f
C443 VDPWR.t14 VGND 0.03136f
C444 VDPWR.n670 VGND 0.04796f
C445 VDPWR.n676 VGND 0.06272f
C446 VDPWR.n683 VGND 0.06272f
C447 VDPWR.n690 VGND 0.08808f
C448 VDPWR.n696 VGND 0.11111f
C449 VDPWR.n697 VGND 0.83765f
C450 VDPWR.t4 VGND 3.75059f
C451 VDPWR.t3 VGND 0.27375f
C452 VDPWR.n702 VGND 0.54749f
C453 VDPWR.n707 VGND 0.54749f
C454 VDPWR.n711 VGND 0.84942f
C455 VDPWR.n887 VGND 0.69644f
C456 VDPWR.n893 VGND 0.41062f
C457 VDPWR.n894 VGND 0.54749f
C458 VDPWR.n1081 VGND 0.84942f
C459 VDPWR.n1082 VGND 0.69644f
C460 VDPWR.n1083 VGND 0.54749f
C461 VDPWR.n1089 VGND 0.41062f
C462 VDPWR.n1092 VGND 0.16409f
C463 charge_high.n0 VGND 10.2132f
C464 charge_low.n0 VGND 10.7108f
C465 share.n0 VGND 11.5054f
C466 vref_high.t0 VGND 0.30302f
C467 vref_high.t1 VGND 0.24145f
C468 vref_high.n0 VGND 30.4994f
C469 vref_low.t0 VGND 0.33095f
C470 vref_low.t1 VGND 0.25411f
C471 vref_low.n0 VGND 31.0343f
C472 vout.t0 VGND 2.28928f
C473 vout.t1 VGND 3.89344f
C474 vout.n0 VGND 7.46083f
C475 vout.n1 VGND 7.02102f
C476 vout.t2 VGND 0.12275p
C477 vout.n2 VGND 14.8043f
* Exact static resistor-node elimination; every capacitive/device/port node preserved.
RRED0 vout.n0 vout.t1 209.708
RRED1 vout.n0 vout.t0 108.117
RRED2 vout.n0 vout.n1 3.37928
RRED3 vout.n1 vout.t4 201.232
RRED4 vout.n1 vout.n2 23.729
RRED5 vout vout.n2 58.7347
RRED6 vout.n2 vout.t2 48.0425
RRED7 vref_low.n0 vref_low.t0 219.865
RRED8 vref_low.n0 vref_low.t1 100.361
RRED9 vref_low.n0 vref_low 62.6061
RRED10 vref_high.n0 vref_high.t0 219.553
RRED11 vref_high.n0 vref_high.t1 100.047
RRED12 vref_high.n0 vref_high 62.2936
RRED13 share.n0 share.t1 567.529
RRED14 share.n0 share.t0 396.466
RRED15 share.n0 share.t2 393.07
RRED16 share.n0 share 14.502
RRED17 charge_low.n0 charge_low.t1 567.216
RRED18 charge_low.n0 charge_low.t0 396.152
RRED19 charge_low.n0 charge_low.t2 392.759
RRED20 charge_low.n0 charge_low 14.1895
RRED21 charge_high.n0 charge_high.t1 566.904
RRED22 charge_high.n0 charge_high.t0 395.841
RRED23 charge_high.n0 charge_high.t2 392.445
RRED24 charge_high.n0 charge_high 13.877
RRED25 VDPWR.n156 VDPWR.n154 143.09541854548
RRED26 VDPWR.n156 VDPWR.n198 177.00637391425
RRED27 VDPWR.n156 VDPWR.n194 1685.4540472442
RRED28 VDPWR.n156 VDPWR.n185 12289.063387642
RRED29 VDPWR.n156 VDPWR.n190 966.53618553119
RRED30 VDPWR.n156 VDPWR.n153 5677.4329808242
RRED31 VDPWR.n156 VDPWR.n158 35216.685773301
RRED32 VDPWR.n156 VDPWR.n188 27146.195283586
RRED33 VDPWR.n156 VDPWR.n187 188499.86435873
RRED34 VDPWR.n208 VDPWR.n206 143.09541854548
RRED35 VDPWR.n208 VDPWR.n250 177.00637391425
RRED36 VDPWR.n208 VDPWR.n246 1685.4540472442
RRED37 VDPWR.n208 VDPWR.n237 12289.063387642
RRED38 VDPWR.n208 VDPWR.n242 966.53618553119
RRED39 VDPWR.n208 VDPWR.n205 5677.4329808242
RRED40 VDPWR.n208 VDPWR.n210 35216.685773301
RRED41 VDPWR.n208 VDPWR.n240 27146.195283586
RRED42 VDPWR.n208 VDPWR.n239 188499.86435873
RRED43 VDPWR.n260 VDPWR.n258 143.09541854548
RRED44 VDPWR.n260 VDPWR.n302 177.00637391425
RRED45 VDPWR.n260 VDPWR.n298 1685.4540472442
RRED46 VDPWR.n260 VDPWR.n289 12289.063387642
RRED47 VDPWR.n260 VDPWR.n294 966.53618553119
RRED48 VDPWR.n260 VDPWR.n257 5677.4329808242
RRED49 VDPWR.n260 VDPWR.n262 35216.685773301
RRED50 VDPWR.n260 VDPWR.n292 27146.195283586
RRED51 VDPWR.n260 VDPWR.n291 188499.86435873
RRED52 VDPWR.n598 VDPWR.n599 184.99505113864
RRED53 VDPWR.n598 VDPWR.n518 1635.5445400952
RRED54 VDPWR.n598 VDPWR.n596 404.66684324833
RRED55 VDPWR.n598 VDPWR.n594 262.97347622758
RRED56 VDPWR.n598 VDPWR.n605 12286.892779842
RRED57 VDPWR.n598 VDPWR.n521 725.35686498668
RRED58 VDPWR.n598 VDPWR.n527 4323.5295969988
RRED59 VDPWR.n598 VDPWR.n592 3332.7207310199
RRED60 VDPWR.n598 VDPWR.n520 613604.12549934
RRED61 VDPWR.n598 VDPWR.n519 8971520.7345306
RRED62 VDPWR.n560 VDPWR.n561 184.91740985585
RRED63 VDPWR.n560 VDPWR.n558 292.11555553858
RRED64 VDPWR.n560 VDPWR.n548 1583.4036618332
RRED65 VDPWR.n560 VDPWR.n544 618.36919502227
RRED66 VDPWR.n560 VDPWR.n567 1538.4302593846
RRED67 VDPWR.n560 VDPWR.n539 627730.66339158
RRED68 VDPWR.n560 VDPWR.n575 153036.03681806
RRED69 VDPWR.n560 VDPWR.n535 3402.5480838273
RRED70 VDPWR.n560 VDPWR.n581 853.36150668696
RRED71 VDPWR.n560 VDPWR.n573 5851.2863542868
RRED72 VDPWR.n560 VDPWR.n540 2981.7142833104
RRED73 VDPWR.n689 VDPWR.n690 184.99505113864
RRED74 VDPWR.n689 VDPWR.n609 1635.5445400952
RRED75 VDPWR.n689 VDPWR.n687 404.66684324833
RRED76 VDPWR.n689 VDPWR.n685 262.97347622758
RRED77 VDPWR.n689 VDPWR.n696 12286.892779842
RRED78 VDPWR.n689 VDPWR.n612 725.35686498668
RRED79 VDPWR.n689 VDPWR.n618 4323.5295969988
RRED80 VDPWR.n689 VDPWR.n683 3332.7207310199
RRED81 VDPWR.n689 VDPWR.n611 613604.12549934
RRED82 VDPWR.n689 VDPWR.n610 8971520.7345306
RRED83 VDPWR.n651 VDPWR.n652 184.91740985585
RRED84 VDPWR.n651 VDPWR.n649 292.11555553858
RRED85 VDPWR.n651 VDPWR.n639 1583.4036618332
RRED86 VDPWR.n651 VDPWR.n635 618.36919502227
RRED87 VDPWR.n651 VDPWR.n658 1538.4302593846
RRED88 VDPWR.n651 VDPWR.n630 627730.66339158
RRED89 VDPWR.n651 VDPWR.n666 153036.03681806
RRED90 VDPWR.n651 VDPWR.n626 3402.5480838273
RRED91 VDPWR.n651 VDPWR.n672 853.36150668696
RRED92 VDPWR.n651 VDPWR.n664 5851.2863542868
RRED93 VDPWR.n651 VDPWR.n631 2981.7142833104
RRED94 VDPWR.n362 VDPWR.n398 184.99111959337
RRED95 VDPWR.n362 VDPWR.n373 320.83030442391
RRED96 VDPWR.n362 VDPWR.n399 654.92635000316
RRED97 VDPWR.n362 VDPWR.n397 1538.8587455638
RRED98 VDPWR.n362 VDPWR.n307 1959.4876151836
RRED99 VDPWR.n362 VDPWR.n305 8170.8273952397
RRED100 VDPWR.n362 VDPWR.n405 6298.3461171639
RRED101 VDPWR.n362 VDPWR.n408 409.58481465085
RRED102 VDPWR.n362 VDPWR.n309 3806398.8685277
RRED103 VDPWR.n362 VDPWR.n403 925191.55947806
RRED104 VDPWR.n468 VDPWR.n504 184.99528387297
RRED105 VDPWR.n468 VDPWR.n479 320.83274084115
RRED106 VDPWR.n468 VDPWR.n505 654.97644885745
RRED107 VDPWR.n468 VDPWR.n503 1539.5234782937
RRED108 VDPWR.n468 VDPWR.n413 1959.4876151836
RRED109 VDPWR.n468 VDPWR.n411 8170.8273952397
RRED110 VDPWR.n468 VDPWR.n511 6298.3461171639
RRED111 VDPWR.n468 VDPWR.n514 409.58481465085
RRED112 VDPWR.n468 VDPWR.n507 536683.74018175
RRED113 VDPWR.n468 VDPWR.n415 43254729.585785
RRED114 VDPWR.n453 VDPWR.n454 184.99022567209
RRED115 VDPWR.n453 VDPWR.n451 290.53680184403
RRED116 VDPWR.n453 VDPWR.n422 1538.7456946925
RRED117 VDPWR.n453 VDPWR.n418 619.41945212678
RRED118 VDPWR.n453 VDPWR.n461 1543.294632977
RRED119 VDPWR.n453 VDPWR.n411 6872436.9383858
RRED120 VDPWR.n453 VDPWR.n514 1023628.2776616
RRED121 VDPWR.n453 VDPWR.n415 3413.6092150138
RRED122 VDPWR.n453 VDPWR.n507 856.23831984653
RRED123 VDPWR.n453 VDPWR.n511 5869.4415825658
RRED124 VDPWR.n453 VDPWR.n460 2989.8931786535
RRED125 VDPWR.n194 VDPWR.n154 246.38075589636
RRED126 VDPWR.n194 VDPWR.n153 123.29691371344
RRED127 VDPWR.n194 VDPWR.n198 979.74449246634
RRED128 VDPWR.n194 VDPWR.n190 652.18065068966
RRED129 VDPWR.n194 VDPWR.n158 11337.578664155
RRED130 VDPWR.n194 VDPWR.n188 8739.3835536196
RRED131 VDPWR.n194 VDPWR.n185 525.60868656433
RRED132 VDPWR.n194 VDPWR.n187 2995.5550561079
RRED133 VDPWR.n154 VDPWR.n198 260.22450244106
RRED134 VDPWR.n154 VDPWR.n185 1693.2310888325
RRED135 VDPWR.n154 VDPWR.n187 25972.185227221
RRED136 VDPWR.n154 VDPWR.n153 20020.22611265
RRED137 VDPWR.n175 VDPWR.n167 202.20287778615
RRED138 VDPWR.n175 VDPWR.n162 127.6404483052
RRED139 VDPWR.n175 VDPWR.n161 584.20267284268
RRED140 VDPWR.n175 VDPWR.n183 705.46176839388
RRED141 VDPWR.n175 VDPWR.n158 2950.2530076068
RRED142 VDPWR.n175 VDPWR.n190 903.68287547011
RRED143 VDPWR.n175 VDPWR.n181 4148.1938634048
RRED144 VDPWR.n167 VDPWR.n161 1526.0827722068
RRED145 VDPWR.n167 VDPWR.n183 473.41749234025
RRED146 VDPWR.n167 VDPWR.n158 3139.3180929504
RRED147 VDPWR.n167 VDPWR.n190 781.42628371416
RRED148 VDPWR.n167 VDPWR.n181 5449.4074141582
RRED149 VDPWR.n167 VDPWR.n162 2841.9232494736
RRED150 VDPWR.n246 VDPWR.n206 246.38075589636
RRED151 VDPWR.n246 VDPWR.n205 123.29691371344
RRED152 VDPWR.n246 VDPWR.n250 979.74449246634
RRED153 VDPWR.n246 VDPWR.n242 652.18065068966
RRED154 VDPWR.n246 VDPWR.n210 11337.578664155
RRED155 VDPWR.n246 VDPWR.n240 8739.3835536196
RRED156 VDPWR.n246 VDPWR.n237 525.60868656433
RRED157 VDPWR.n246 VDPWR.n239 2995.5550561079
RRED158 VDPWR.n206 VDPWR.n250 260.22450244106
RRED159 VDPWR.n206 VDPWR.n237 1693.2310888325
RRED160 VDPWR.n206 VDPWR.n239 25972.185227221
RRED161 VDPWR.n206 VDPWR.n205 20020.22611265
RRED162 VDPWR.n227 VDPWR.n219 202.20287778615
RRED163 VDPWR.n227 VDPWR.n214 127.6404483052
RRED164 VDPWR.n227 VDPWR.n213 584.20267284268
RRED165 VDPWR.n227 VDPWR.n235 705.46176839388
RRED166 VDPWR.n227 VDPWR.n210 2950.2530076068
RRED167 VDPWR.n227 VDPWR.n242 903.68287547011
RRED168 VDPWR.n227 VDPWR.n233 4148.1938634048
RRED169 VDPWR.n219 VDPWR.n213 1526.0827722068
RRED170 VDPWR.n219 VDPWR.n235 473.41749234025
RRED171 VDPWR.n219 VDPWR.n210 3139.3180929504
RRED172 VDPWR.n219 VDPWR.n242 781.42628371416
RRED173 VDPWR.n219 VDPWR.n233 5449.4074141582
RRED174 VDPWR.n219 VDPWR.n214 2841.9232494736
RRED175 VDPWR.n298 VDPWR.n258 246.38075589636
RRED176 VDPWR.n298 VDPWR.n257 123.29691371344
RRED177 VDPWR.n298 VDPWR.n302 979.74449246634
RRED178 VDPWR.n298 VDPWR.n294 652.18065068966
RRED179 VDPWR.n298 VDPWR.n262 11337.578664155
RRED180 VDPWR.n298 VDPWR.n292 8739.3835536196
RRED181 VDPWR.n298 VDPWR.n289 525.60868656433
RRED182 VDPWR.n298 VDPWR.n291 2995.5550561079
RRED183 VDPWR.n258 VDPWR.n302 260.22450244106
RRED184 VDPWR.n258 VDPWR.n289 1693.2310888325
RRED185 VDPWR.n258 VDPWR.n291 25972.185227221
RRED186 VDPWR.n258 VDPWR.n257 20020.22611265
RRED187 VDPWR.n279 VDPWR.n271 202.20287778615
RRED188 VDPWR.n279 VDPWR.n266 127.6404483052
RRED189 VDPWR.n279 VDPWR.n265 584.20267284268
RRED190 VDPWR.n279 VDPWR.n287 705.46176839388
RRED191 VDPWR.n279 VDPWR.n262 2950.2530076068
RRED192 VDPWR.n279 VDPWR.n294 903.68287547011
RRED193 VDPWR.n279 VDPWR.n285 4148.1938634048
RRED194 VDPWR.n271 VDPWR.n265 1526.0827722068
RRED195 VDPWR.n271 VDPWR.n287 473.41749234025
RRED196 VDPWR.n271 VDPWR.n262 3139.3180929504
RRED197 VDPWR.n271 VDPWR.n294 781.42628371416
RRED198 VDPWR.n271 VDPWR.n285 5449.4074141582
RRED199 VDPWR.n271 VDPWR.n266 2841.9232494736
RRED200 VDPWR.n158 VDPWR.n163 185
RRED201 VDPWR.n158 VDPWR.n190 158.01752996311
RRED202 VDPWR.n158 VDPWR.n181 671.09330220048
RRED203 VDPWR.n158 VDPWR.n188 805.3797524936
RRED204 VDPWR.n158 VDPWR.n153 3339.1848440543
RRED205 VDPWR.n158 VDPWR.n198 18748.826204484
RRED206 VDPWR.n158 VDPWR.n161 23320.29450107
RRED207 VDPWR.n158 VDPWR.n183 5636.7260697592
RRED208 VDPWR.n158 VDPWR.n162 1794.4244416887
RRED209 VDPWR.n187 VDPWR.n188 185
RRED210 VDPWR.n187 VDPWR.n153 800.55894420126
RRED211 VDPWR.n187 VDPWR.n185 195.95624492129
RRED212 VDPWR.n187 VDPWR.n183 384.87558611479
RRED213 VDPWR.n187 VDPWR.n163 752.06676427935
RRED214 VDPWR.n187 VDPWR.n161 4482.7354247768
RRED215 VDPWR.n187 VDPWR.n181 3455.4418899321
RRED216 VDPWR.n187 VDPWR.n198 12289.076128618
RRED217 VDPWR.n161 VDPWR.n162 183.55648051341
RRED218 VDPWR.n161 VDPWR.n183 157.15976085553
RRED219 VDPWR.n161 VDPWR.n181 793.38307140902
RRED220 VDPWR.n161 VDPWR.n163 3629.0725753549
RRED221 VDPWR.n161 VDPWR.n185 12965.491956379
RRED222 VDPWR.n161 VDPWR.n190 5672.4154589695
RRED223 VDPWR.n210 VDPWR.n215 185
RRED224 VDPWR.n210 VDPWR.n242 158.01752996311
RRED225 VDPWR.n210 VDPWR.n233 671.09330220048
RRED226 VDPWR.n210 VDPWR.n240 805.3797524936
RRED227 VDPWR.n210 VDPWR.n205 3339.1848440543
RRED228 VDPWR.n210 VDPWR.n250 18748.826204484
RRED229 VDPWR.n210 VDPWR.n213 23320.29450107
RRED230 VDPWR.n210 VDPWR.n235 5636.7260697592
RRED231 VDPWR.n210 VDPWR.n214 1794.4244416887
RRED232 VDPWR.n239 VDPWR.n240 185
RRED233 VDPWR.n239 VDPWR.n205 800.55894420126
RRED234 VDPWR.n239 VDPWR.n237 195.95624492129
RRED235 VDPWR.n239 VDPWR.n235 384.87558611479
RRED236 VDPWR.n239 VDPWR.n215 752.06676427935
RRED237 VDPWR.n239 VDPWR.n213 4482.7354247768
RRED238 VDPWR.n239 VDPWR.n233 3455.4418899321
RRED239 VDPWR.n239 VDPWR.n250 12289.076128618
RRED240 VDPWR.n213 VDPWR.n214 183.55648051341
RRED241 VDPWR.n213 VDPWR.n235 157.15976085553
RRED242 VDPWR.n213 VDPWR.n233 793.38307140902
RRED243 VDPWR.n213 VDPWR.n215 3629.0725753549
RRED244 VDPWR.n213 VDPWR.n237 12965.491956379
RRED245 VDPWR.n213 VDPWR.n242 5672.4154589695
RRED246 VDPWR.n262 VDPWR.n267 185
RRED247 VDPWR.n262 VDPWR.n294 158.01752996311
RRED248 VDPWR.n262 VDPWR.n285 671.09330220048
RRED249 VDPWR.n262 VDPWR.n292 805.3797524936
RRED250 VDPWR.n262 VDPWR.n257 3339.1848440543
RRED251 VDPWR.n262 VDPWR.n302 18748.826204484
RRED252 VDPWR.n262 VDPWR.n265 23320.29450107
RRED253 VDPWR.n262 VDPWR.n287 5636.7260697592
RRED254 VDPWR.n262 VDPWR.n266 1794.4244416887
RRED255 VDPWR.n291 VDPWR.n292 185
RRED256 VDPWR.n291 VDPWR.n257 800.55894420126
RRED257 VDPWR.n291 VDPWR.n289 195.95624492129
RRED258 VDPWR.n291 VDPWR.n287 384.87558611479
RRED259 VDPWR.n291 VDPWR.n267 752.06676427935
RRED260 VDPWR.n291 VDPWR.n265 4482.7354247768
RRED261 VDPWR.n291 VDPWR.n285 3455.4418899321
RRED262 VDPWR.n291 VDPWR.n302 12289.076128618
RRED263 VDPWR.n265 VDPWR.n266 183.55648051341
RRED264 VDPWR.n265 VDPWR.n287 157.15976085553
RRED265 VDPWR.n265 VDPWR.n285 793.38307140902
RRED266 VDPWR.n265 VDPWR.n267 3629.0725753549
RRED267 VDPWR.n265 VDPWR.n289 12965.491956379
RRED268 VDPWR.n265 VDPWR.n294 5672.4154589695
RRED269 VDPWR.n305 VDPWR.n354 185
RRED270 VDPWR.n305 VDPWR.n408 146.58034083595
RRED271 VDPWR.n305 VDPWR.n355 709.42453987683
RRED272 VDPWR.n305 VDPWR.n405 786.43886272734
RRED273 VDPWR.n305 VDPWR.n307 3085.5708975354
RRED274 VDPWR.n305 VDPWR.n399 10890.729552547
RRED275 VDPWR.n305 VDPWR.n373 8320.1166120171
RRED276 VDPWR.n305 VDPWR.n348 4138.8494524179
RRED277 VDPWR.n305 VDPWR.n316 2541.1215500595
RRED278 VDPWR.n305 VDPWR.n346 62007.363511206
RRED279 VDPWR.n305 VDPWR.n311 4484843.8365214
RRED280 VDPWR.n305 VDPWR.n312 2111.5115222312
RRED281 VDPWR.n309 VDPWR.n307 185
RRED282 VDPWR.n309 VDPWR.n403 157.8407353612
RRED283 VDPWR.n309 VDPWR.n399 665.27105316175
RRED284 VDPWR.n309 VDPWR.n405 806.16703550364
RRED285 VDPWR.n309 VDPWR.n398 1668.7925850769
RRED286 VDPWR.n309 VDPWR.n354 3402.4826584696
RRED287 VDPWR.n309 VDPWR.n311 15216.876442044
RRED288 VDPWR.n309 VDPWR.n355 14138.720887244
RRED289 VDPWR.n309 VDPWR.n346 12358.546288811
RRED290 VDPWR.n309 VDPWR.n397 1422.1012750884
RRED291 VDPWR.n309 VDPWR.n373 17851.404611129
RRED292 VDPWR.n311 VDPWR.n312 184.99007744421
RRED293 VDPWR.n311 VDPWR.n346 178.88108970973
RRED294 VDPWR.n311 VDPWR.n348 718.57716127712
RRED295 VDPWR.n311 VDPWR.n355 716.72783915294
RRED296 VDPWR.n311 VDPWR.n403 536.34830911276
RRED297 VDPWR.n311 VDPWR.n316 4273.4609474284
RRED298 VDPWR.n311 VDPWR.n354 2552.9293932791
RRED299 VDPWR.n311 VDPWR.n405 11729.675590742
RRED300 VDPWR.n311 VDPWR.n408 668003.58700118
RRED301 VDPWR.n411 VDPWR.n460 185
RRED302 VDPWR.n411 VDPWR.n514 146.58597587051
RRED303 VDPWR.n411 VDPWR.n461 709.43819785801
RRED304 VDPWR.n411 VDPWR.n511 786.43886272734
RRED305 VDPWR.n411 VDPWR.n413 3085.5708975354
RRED306 VDPWR.n411 VDPWR.n505 10890.729552547
RRED307 VDPWR.n411 VDPWR.n479 8320.1166120171
RRED308 VDPWR.n411 VDPWR.n454 4145.1283133785
RRED309 VDPWR.n411 VDPWR.n422 2635.3904947336
RRED310 VDPWR.n411 VDPWR.n451 32230.568814434
RRED311 VDPWR.n411 VDPWR.n418 2111.7380606461
RRED312 VDPWR.n415 VDPWR.n413 185
RRED313 VDPWR.n415 VDPWR.n507 161.18322029035
RRED314 VDPWR.n415 VDPWR.n505 800.42373768173
RRED315 VDPWR.n415 VDPWR.n511 680.51383014618
RRED316 VDPWR.n415 VDPWR.n504 2986.8809092641
RRED317 VDPWR.n415 VDPWR.n451 2255.8038376875
RRED318 VDPWR.n415 VDPWR.n461 3986.2768034373
RRED319 VDPWR.n415 VDPWR.n418 7513.0459939237
RRED320 VDPWR.n415 VDPWR.n460 1926.626167413
RRED321 VDPWR.n415 VDPWR.n503 10745.718810627
RRED322 VDPWR.n415 VDPWR.n479 202858.46429023
RRED323 VDPWR.n527 VDPWR.n528 185
RRED324 VDPWR.n527 VDPWR.n594 180.14926660624
RRED325 VDPWR.n527 VDPWR.n585 716.8074139327
RRED326 VDPWR.n527 VDPWR.n592 808.62210291451
RRED327 VDPWR.n527 VDPWR.n581 536.34830911276
RRED328 VDPWR.n527 VDPWR.n521 3615.3381291972
RRED329 VDPWR.n527 VDPWR.n596 23973.415270908
RRED330 VDPWR.n527 VDPWR.n532 2552.9293932791
RRED331 VDPWR.n527 VDPWR.n535 15216.876442044
RRED332 VDPWR.n527 VDPWR.n579 11729.675590742
RRED333 VDPWR.n535 VDPWR.n536 185
RRED334 VDPWR.n535 VDPWR.n581 162.81243442431
RRED335 VDPWR.n535 VDPWR.n573 680.47599755678
RRED336 VDPWR.n535 VDPWR.n579 806.16703550364
RRED337 VDPWR.n535 VDPWR.n532 3402.4826584696
RRED338 VDPWR.n535 VDPWR.n585 14138.720887244
RRED339 VDPWR.n535 VDPWR.n594 12358.546288811
RRED340 VDPWR.n535 VDPWR.n558 2267.7322331218
RRED341 VDPWR.n535 VDPWR.n567 3983.1939330551
RRED342 VDPWR.n535 VDPWR.n544 7501.4267011771
RRED343 VDPWR.n535 VDPWR.n540 1926.1000145169
RRED344 VDPWR.n519 VDPWR.n521 185
RRED345 VDPWR.n519 VDPWR.n520 179.79653226339
RRED346 VDPWR.n519 VDPWR.n592 716.8074139327
RRED347 VDPWR.n519 VDPWR.n599 718.6037156012
RRED348 VDPWR.n519 VDPWR.n587 536.34830911276
RRED349 VDPWR.n519 VDPWR.n518 5839.9011945226
RRED350 VDPWR.n519 VDPWR.n605 10898.590271439
RRED351 VDPWR.n519 VDPWR.n528 2552.9293932791
RRED352 VDPWR.n519 VDPWR.n531 15216.876442044
RRED353 VDPWR.n519 VDPWR.n585 11729.675590742
RRED354 VDPWR.n519 VDPWR.n596 780055.98655604
RRED355 VDPWR.n531 VDPWR.n532 185
RRED356 VDPWR.n531 VDPWR.n587 179.12720470961
RRED357 VDPWR.n531 VDPWR.n579 716.8074139327
RRED358 VDPWR.n531 VDPWR.n585 806.16703550364
RRED359 VDPWR.n531 VDPWR.n575 536.34830911276
RRED360 VDPWR.n531 VDPWR.n528 3402.4826584696
RRED361 VDPWR.n531 VDPWR.n592 14138.720887244
RRED362 VDPWR.n531 VDPWR.n520 12358.546288811
RRED363 VDPWR.n531 VDPWR.n536 2552.9293932791
RRED364 VDPWR.n531 VDPWR.n539 15216.876442044
RRED365 VDPWR.n531 VDPWR.n573 11729.675590742
RRED366 VDPWR.n539 VDPWR.n540 185
RRED367 VDPWR.n539 VDPWR.n575 159.76453256746
RRED368 VDPWR.n539 VDPWR.n567 672.9064602401
RRED369 VDPWR.n539 VDPWR.n573 806.16703550364
RRED370 VDPWR.n539 VDPWR.n536 3402.4826584696
RRED371 VDPWR.n539 VDPWR.n579 14138.720887244
RRED372 VDPWR.n539 VDPWR.n587 12358.546288811
RRED373 VDPWR.n539 VDPWR.n561 3282.5242156095
RRED374 VDPWR.n539 VDPWR.n548 3602.5498557567
RRED375 VDPWR.n539 VDPWR.n558 2925.8901995911
RRED376 VDPWR.n539 VDPWR.n544 1817.6662316121
RRED377 VDPWR.n618 VDPWR.n619 185
RRED378 VDPWR.n618 VDPWR.n685 180.14926660624
RRED379 VDPWR.n618 VDPWR.n676 716.8074139327
RRED380 VDPWR.n618 VDPWR.n683 808.62210291451
RRED381 VDPWR.n618 VDPWR.n672 536.34830911276
RRED382 VDPWR.n618 VDPWR.n612 3615.3381291972
RRED383 VDPWR.n618 VDPWR.n687 23973.415270908
RRED384 VDPWR.n618 VDPWR.n623 2552.9293932791
RRED385 VDPWR.n618 VDPWR.n626 15216.876442044
RRED386 VDPWR.n618 VDPWR.n670 11729.675590742
RRED387 VDPWR.n626 VDPWR.n627 185
RRED388 VDPWR.n626 VDPWR.n672 162.81243442431
RRED389 VDPWR.n626 VDPWR.n664 680.47599755678
RRED390 VDPWR.n626 VDPWR.n670 806.16703550364
RRED391 VDPWR.n626 VDPWR.n623 3402.4826584696
RRED392 VDPWR.n626 VDPWR.n676 14138.720887244
RRED393 VDPWR.n626 VDPWR.n685 12358.546288811
RRED394 VDPWR.n626 VDPWR.n649 2267.7322331218
RRED395 VDPWR.n626 VDPWR.n658 3983.1939330551
RRED396 VDPWR.n626 VDPWR.n635 7501.4267011771
RRED397 VDPWR.n626 VDPWR.n631 1926.1000145169
RRED398 VDPWR.n610 VDPWR.n612 185
RRED399 VDPWR.n610 VDPWR.n611 179.79653226339
RRED400 VDPWR.n610 VDPWR.n683 716.8074139327
RRED401 VDPWR.n610 VDPWR.n690 718.6037156012
RRED402 VDPWR.n610 VDPWR.n678 536.34830911276
RRED403 VDPWR.n610 VDPWR.n609 5839.9011945226
RRED404 VDPWR.n610 VDPWR.n696 10898.590271439
RRED405 VDPWR.n610 VDPWR.n619 2552.9293932791
RRED406 VDPWR.n610 VDPWR.n622 15216.876442044
RRED407 VDPWR.n610 VDPWR.n676 11729.675590742
RRED408 VDPWR.n610 VDPWR.n687 780055.98655604
RRED409 VDPWR.n622 VDPWR.n623 185
RRED410 VDPWR.n622 VDPWR.n678 179.12720470961
RRED411 VDPWR.n622 VDPWR.n670 716.8074139327
RRED412 VDPWR.n622 VDPWR.n676 806.16703550364
RRED413 VDPWR.n622 VDPWR.n666 536.34830911276
RRED414 VDPWR.n622 VDPWR.n619 3402.4826584696
RRED415 VDPWR.n622 VDPWR.n683 14138.720887244
RRED416 VDPWR.n622 VDPWR.n611 12358.546288811
RRED417 VDPWR.n622 VDPWR.n627 2552.9293932791
RRED418 VDPWR.n622 VDPWR.n630 15216.876442044
RRED419 VDPWR.n622 VDPWR.n664 11729.675590742
RRED420 VDPWR.n630 VDPWR.n631 185
RRED421 VDPWR.n630 VDPWR.n666 159.76453256746
RRED422 VDPWR.n630 VDPWR.n658 672.9064602401
RRED423 VDPWR.n630 VDPWR.n664 806.16703550364
RRED424 VDPWR.n630 VDPWR.n627 3402.4826584696
RRED425 VDPWR.n630 VDPWR.n670 14138.720887244
RRED426 VDPWR.n630 VDPWR.n678 12358.546288811
RRED427 VDPWR.n630 VDPWR.n652 3282.5242156095
RRED428 VDPWR.n630 VDPWR.n639 3602.5498557567
RRED429 VDPWR.n630 VDPWR.n649 2925.8901995911
RRED430 VDPWR.n630 VDPWR.n635 1817.6662316121
RRED431 VDPWR.n900 VDPWR.n1083 185
RRED432 VDPWR.n900 VDPWR.n942 185.93072235399
RRED433 VDPWR.n900 VDPWR.n702 732.2092796877
RRED434 VDPWR.n900 VDPWR.n1082 720.22961378254
RRED435 VDPWR.n900 VDPWR.n1092 475.85434956295
RRED436 VDPWR.n900 VDPWR.n700 3834.722704469
RRED437 VDPWR.n900 VDPWR.n1089 2955.9320846948
RRED438 VDPWR.n900 VDPWR.n1081 4143.6105732493
RRED439 VDPWR.n900 VDPWR.n1084 8252540624949.4
RRED440 VDPWR.n900 VDPWR.n1086 1994398037043.9
RRED441 VDPWR.n700 VDPWR.n893 185
RRED442 VDPWR.n700 VDPWR.n1092 167.08267323175
RRED443 VDPWR.n700 VDPWR.n708 895.87475252187
RRED444 VDPWR.n700 VDPWR.n894 791.9331196276
RRED445 VDPWR.n700 VDPWR.n889 968.57460039721
RRED446 VDPWR.n700 VDPWR.n1089 791.87821548687
RRED447 VDPWR.n700 VDPWR.n702 3389.8085705711
RRED448 VDPWR.n700 VDPWR.n942 4145.9087898835
RRED449 VDPWR.n708 VDPWR.n707 184.99999999816
RRED450 VDPWR.n708 VDPWR.n889 188.19169940572
RRED451 VDPWR.n708 VDPWR.n887 720.22961449314
RRED452 VDPWR.n708 VDPWR.n894 777.18173345677
RRED453 VDPWR.n708 VDPWR.n1092 556.22303102185
RRED454 VDPWR.n708 VDPWR.n711 4143.6096793105
RRED455 VDPWR.n708 VDPWR.n895 10391872214579
RRED456 VDPWR.n708 VDPWR.n897 2525884495790.7
RRED457 VDPWR.n1084 VDPWR.n1083 185
RRED458 VDPWR.n1084 VDPWR.n1086 158.77082052422
RRED459 VDPWR.n1084 VDPWR.n702 806.90654715502
RRED460 VDPWR.n1084 VDPWR.n1081 938.18036725304
RRED461 VDPWR.n1084 VDPWR.n1082 610.48649135264
RRED462 VDPWR.n1084 VDPWR.n1089 3464.0461919046
RRED463 VDPWR.n1084 VDPWR.n897 5054.8576486969
RRED464 VDPWR.n1084 VDPWR.n895 20647.638368109
RRED465 VDPWR.n1084 VDPWR.n893 15915.887908751
RRED466 VDPWR.n1084 VDPWR.n942 113874112081.57
RRED467 VDPWR.n895 VDPWR.n894 185
RRED468 VDPWR.n895 VDPWR.n893 806.90654715502
RRED469 VDPWR.n895 VDPWR.n897 160.07504892127
RRED470 VDPWR.n895 VDPWR.n707 665.56525513753
RRED471 VDPWR.n895 VDPWR.n1089 3464.0461919046
RRED472 VDPWR.n895 VDPWR.n1086 5054.8576486969
RRED473 VDPWR.n895 VDPWR.n702 15915.887908751
RRED474 VDPWR.n895 VDPWR.n711 1304.3522468432
RRED475 VDPWR.n895 VDPWR.n889 143393980534.12
RRED476 VDPWR.n895 VDPWR.n887 1673.0983866015
RRED477 VDPWR.n53 VDPWR.t13 216.494
RRED478 VDPWR.n53 VDPWR.n52 21.4219
RRED479 VDPWR.n53 VDPWR.n4 1.34261
RRED480 VDPWR.n4 VDPWR.t16 216.3
RRED481 VDPWR.n4 VDPWR.n100 21.4219
RRED482 VDPWR.n4 VDPWR.n3 1.72906
RRED483 VDPWR.n3 VDPWR.t11 216.3
RRED484 VDPWR.n3 VDPWR.n147 21.4219
RRED485 VDPWR.n3 VDPWR.n199 1.5515
RRED486 VDPWR.n5 VDPWR.t4 204.083
RRED487 VDPWR.n5 VDPWR.n1092 23.9219
RRED488 VDPWR.n5 VDPWR.n2 5.57772
RRED489 VDPWR.n5 VDPWR.n697 3.5725
RRED490 VDPWR.n599 VDPWR.n518 189.09089936259
RRED491 VDPWR.n599 VDPWR.n521 109.123
RRED492 VDPWR.n599 VDPWR.n520 536.04065295081
RRED493 VDPWR.n599 VDPWR.n605 8400.9966675679
RRED494 VDPWR.n599 VDPWR.n596 601293.15630361
RRED495 VDPWR.n518 VDPWR.n605 138.01963739344
RRED496 VDPWR.n518 VDPWR.n596 266.47671492218
RRED497 VDPWR.n518 VDPWR.n520 654.10776786923
RRED498 VDPWR.n561 VDPWR.n548 176.72856012411
RRED499 VDPWR.n561 VDPWR.n544 101.91680352102
RRED500 VDPWR.n561 VDPWR.n558 2020.5866838405
RRED501 VDPWR.n561 VDPWR.n575 1034.9535947093
RRED502 VDPWR.n561 VDPWR.n567 4509.4829404911
RRED503 VDPWR.n548 VDPWR.n558 118.32056039325
RRED504 VDPWR.n548 VDPWR.n575 900.69545795494
RRED505 VDPWR.n548 VDPWR.n567 6219.2500260694
RRED506 VDPWR.n548 VDPWR.n544 3199.384215451
RRED507 VDPWR.n690 VDPWR.n609 189.09089936259
RRED508 VDPWR.n690 VDPWR.n612 109.123
RRED509 VDPWR.n690 VDPWR.n611 536.04065295081
RRED510 VDPWR.n690 VDPWR.n696 8400.9966675679
RRED511 VDPWR.n690 VDPWR.n687 601293.15630361
RRED512 VDPWR.n609 VDPWR.n696 138.01963739344
RRED513 VDPWR.n609 VDPWR.n687 266.47671492218
RRED514 VDPWR.n609 VDPWR.n611 654.10776786923
RRED515 VDPWR.n652 VDPWR.n639 176.72856012411
RRED516 VDPWR.n652 VDPWR.n635 101.91680352102
RRED517 VDPWR.n652 VDPWR.n649 2020.5866838405
RRED518 VDPWR.n652 VDPWR.n666 1034.9535947093
RRED519 VDPWR.n652 VDPWR.n658 4509.4829404911
RRED520 VDPWR.n639 VDPWR.n649 118.32056039325
RRED521 VDPWR.n639 VDPWR.n666 900.69545795494
RRED522 VDPWR.n639 VDPWR.n658 6219.2500260694
RRED523 VDPWR.n639 VDPWR.n635 3199.384215451
RRED524 VDPWR.n17 VDPWR.n28 124.87730781456
RRED525 VDPWR.n17 VDPWR.t12 42.0578
RRED526 VDPWR.n17 VDPWR.n49 702.48484124814
RRED527 VDPWR.n17 VDPWR.n52 379.27256188352
RRED528 VDPWR.n17 VDPWR.n10 1112.9971605655
RRED529 VDPWR.n49 VDPWR.n10 124.87731988839
RRED530 VDPWR.n49 VDPWR.t12 42.0578
RRED531 VDPWR.n49 VDPWR.n52 379.27247873265
RRED532 VDPWR.n49 VDPWR.n28 1112.997102522
RRED533 VDPWR.n10 VDPWR.n52 200.26999120383
RRED534 VDPWR.n10 VDPWR.n28 745.74292957555
RRED535 VDPWR.n28 VDPWR.n52 200.26979133252
RRED536 VDPWR.n65 VDPWR.n76 124.87730781456
RRED537 VDPWR.n65 VDPWR.t15 42.0578
RRED538 VDPWR.n65 VDPWR.n100 379.27256188352
RRED539 VDPWR.n65 VDPWR.n97 702.48484124814
RRED540 VDPWR.n65 VDPWR.n58 1112.9971605655
RRED541 VDPWR.n97 VDPWR.n58 124.87731988839
RRED542 VDPWR.n97 VDPWR.t15 42.0578
RRED543 VDPWR.n97 VDPWR.n100 379.27247873265
RRED544 VDPWR.n97 VDPWR.n76 1112.997102522
RRED545 VDPWR.n58 VDPWR.n100 200.26999120383
RRED546 VDPWR.n58 VDPWR.n76 745.74292957555
RRED547 VDPWR.n76 VDPWR.n100 200.26979133252
RRED548 VDPWR.n112 VDPWR.n123 124.87730781456
RRED549 VDPWR.n112 VDPWR.t10 42.0578
RRED550 VDPWR.n112 VDPWR.n147 379.27256188352
RRED551 VDPWR.n112 VDPWR.n144 702.48484124814
RRED552 VDPWR.n112 VDPWR.n105 1112.9971605655
RRED553 VDPWR.n144 VDPWR.n105 124.87731988839
RRED554 VDPWR.n144 VDPWR.t10 42.0578
RRED555 VDPWR.n144 VDPWR.n147 379.27247873265
RRED556 VDPWR.n144 VDPWR.n123 1112.997102522
RRED557 VDPWR.n105 VDPWR.n147 200.26999120383
RRED558 VDPWR.n105 VDPWR.n123 745.74292957555
RRED559 VDPWR.n123 VDPWR.n147 200.26979133252
RRED560 VDPWR.n198 VDPWR.n199 21.4219
RRED561 VDPWR.n198 VDPWR.n185 147.30336497864
RRED562 VDPWR.n198 VDPWR.n190 206.75552730233
RRED563 VDPWR.n198 VDPWR.n153 2361.3796004786
RRED564 VDPWR.n198 VDPWR.n188 14452.22019929
RRED565 VDPWR.n153 VDPWR.n188 132.62244560154
RRED566 VDPWR.n153 VDPWR.n185 515.37947802732
RRED567 VDPWR.n153 VDPWR.n190 520.97263099107
RRED568 VDPWR.n185 VDPWR.n183 88.427532371832
RRED569 VDPWR.n185 VDPWR.n163 2175.2155010151
RRED570 VDPWR.n185 VDPWR.n181 9994.2333830425
RRED571 VDPWR.n188 VDPWR.t1 65.8014
RRED572 VDPWR.n188 VDPWR.n190 514.40256872876
RRED573 VDPWR.n163 VDPWR.n181 133.17054388302
RRED574 VDPWR.n163 VDPWR.t1 74.0265
RRED575 VDPWR.n163 VDPWR.n183 745.96814378967
RRED576 VDPWR.n181 VDPWR.n162 130.43001326997
RRED577 VDPWR.n181 VDPWR.n183 521.60748234593
RRED578 VDPWR.n181 VDPWR.n190 892.57459126975
RRED579 VDPWR.n183 VDPWR.n190 1370.4227149678
RRED580 VDPWR.n183 VDPWR.n162 5699.6438428001
RRED581 VDPWR.n162 VDPWR.n190 864.29825799442
RRED582 VDPWR.n250 VDPWR.n251 21.4219
RRED583 VDPWR.n250 VDPWR.n237 147.30336497864
RRED584 VDPWR.n250 VDPWR.n242 206.75552730233
RRED585 VDPWR.n250 VDPWR.n205 2361.3796004786
RRED586 VDPWR.n250 VDPWR.n240 14452.22019929
RRED587 VDPWR.n205 VDPWR.n240 132.62244560154
RRED588 VDPWR.n205 VDPWR.n237 515.37947802732
RRED589 VDPWR.n205 VDPWR.n242 520.97263099107
RRED590 VDPWR.n237 VDPWR.n235 88.427532371832
RRED591 VDPWR.n237 VDPWR.n215 2175.2155010151
RRED592 VDPWR.n237 VDPWR.n233 9994.2333830425
RRED593 VDPWR.n240 VDPWR.t0 65.8014
RRED594 VDPWR.n240 VDPWR.n242 514.40256872876
RRED595 VDPWR.n215 VDPWR.n233 133.17054388302
RRED596 VDPWR.n215 VDPWR.t0 74.0265
RRED597 VDPWR.n215 VDPWR.n235 745.96814378967
RRED598 VDPWR.n233 VDPWR.n214 130.43001326997
RRED599 VDPWR.n233 VDPWR.n235 521.60748234593
RRED600 VDPWR.n233 VDPWR.n242 892.57459126975
RRED601 VDPWR.n235 VDPWR.n242 1370.4227149678
RRED602 VDPWR.n235 VDPWR.n214 5699.6438428001
RRED603 VDPWR.n214 VDPWR.n242 864.29825799442
RRED604 VDPWR.n302 VDPWR.n0 21.4219
RRED605 VDPWR.n302 VDPWR.n289 147.30336497864
RRED606 VDPWR.n302 VDPWR.n294 206.75552730233
RRED607 VDPWR.n302 VDPWR.n257 2361.3796004786
RRED608 VDPWR.n302 VDPWR.n292 14452.22019929
RRED609 VDPWR.n257 VDPWR.n292 132.62244560154
RRED610 VDPWR.n257 VDPWR.n289 515.37947802732
RRED611 VDPWR.n257 VDPWR.n294 520.97263099107
RRED612 VDPWR.n289 VDPWR.n287 88.427532371832
RRED613 VDPWR.n289 VDPWR.n267 2175.2155010151
RRED614 VDPWR.n289 VDPWR.n285 9994.2333830425
RRED615 VDPWR.n292 VDPWR.t2 65.8014
RRED616 VDPWR.n292 VDPWR.n294 514.40256872876
RRED617 VDPWR.n267 VDPWR.n285 133.17054388302
RRED618 VDPWR.n267 VDPWR.t2 74.0265
RRED619 VDPWR.n267 VDPWR.n287 745.96814378967
RRED620 VDPWR.n285 VDPWR.n266 130.43001326997
RRED621 VDPWR.n285 VDPWR.n287 521.60748234593
RRED622 VDPWR.n285 VDPWR.n294 892.57459126975
RRED623 VDPWR.n287 VDPWR.n294 1370.4227149678
RRED624 VDPWR.n287 VDPWR.n266 5699.6438428001
RRED625 VDPWR.n266 VDPWR.n294 864.29825799442
RRED626 VDPWR.n348 VDPWR.n316 77.084341770758
RRED627 VDPWR.n348 VDPWR.n312 53.421068476115
RRED628 VDPWR.n348 VDPWR.n346 517.0337128381
RRED629 VDPWR.n348 VDPWR.n408 866.27343867108
RRED630 VDPWR.n348 VDPWR.n355 4765.8793445162
RRED631 VDPWR.n312 VDPWR.n355 53.834041367698
RRED632 VDPWR.n312 VDPWR.n408 753.52236318794
RRED633 VDPWR.n312 VDPWR.n316 1826.135661165
RRED634 VDPWR.n312 VDPWR.n346 47686.187805329
RRED635 VDPWR.n355 VDPWR.n354 54.048459704099
RRED636 VDPWR.n355 VDPWR.n408 776.19334812535
RRED637 VDPWR.n355 VDPWR.n346 1350.5674422781
RRED638 VDPWR.n355 VDPWR.n403 982.1934805296
RRED639 VDPWR.n355 VDPWR.n405 10898.597350584
RRED640 VDPWR.n355 VDPWR.n316 3597.0565822743
RRED641 VDPWR.n354 VDPWR.t7 27.6546
RRED642 VDPWR.n354 VDPWR.n403 594.2435843762
RRED643 VDPWR.n354 VDPWR.n405 2622.747049237
RRED644 VDPWR.n354 VDPWR.n346 2073.388464385
RRED645 VDPWR.n405 VDPWR.n307 54.051780571201
RRED646 VDPWR.n405 VDPWR.t7 27.6546
RRED647 VDPWR.n405 VDPWR.n403 528.40406713884
RRED648 VDPWR.n405 VDPWR.n399 8394.9373634214
RRED649 VDPWR.n405 VDPWR.n373 6413.4232217632
RRED650 VDPWR.n405 VDPWR.n346 9526.3794309582
RRED651 VDPWR.n405 VDPWR.n408 613.49236174182
RRED652 VDPWR.n307 VDPWR.n399 53.947972901358
RRED653 VDPWR.n307 VDPWR.n373 2703.801206589
RRED654 VDPWR.n307 VDPWR.n408 653.48447740541
RRED655 VDPWR.n399 VDPWR.n398 53.637795781139
RRED656 VDPWR.n399 VDPWR.n373 1941.4701426361
RRED657 VDPWR.n399 VDPWR.n403 873.38604051705
RRED658 VDPWR.n399 VDPWR.n408 983.52660243856
RRED659 VDPWR.n399 VDPWR.n397 2391.5937427665
RRED660 VDPWR.n398 VDPWR.n397 79.53073456334
RRED661 VDPWR.n398 VDPWR.n403 838.27804344739
RRED662 VDPWR.n398 VDPWR.n373 18073.777367249
RRED663 VDPWR.n373 VDPWR.n397 89.675560926377
RRED664 VDPWR.n373 VDPWR.n408 259.01496301046
RRED665 VDPWR.n373 VDPWR.n403 4338.9989679723
RRED666 VDPWR.n397 VDPWR.n403 363.32383236575
RRED667 VDPWR.n403 VDPWR.n346 128.17192738228
RRED668 VDPWR.n346 VDPWR.n316 166.33725488476
RRED669 VDPWR.n346 VDPWR.n408 9235.8042761008
RRED670 VDPWR.n316 VDPWR.n408 386.04773390313
RRED671 VDPWR.n454 VDPWR.n422 79.103887835601
RRED672 VDPWR.n454 VDPWR.n418 53.422426730765
RRED673 VDPWR.n454 VDPWR.n451 16420.708406334
RRED674 VDPWR.n454 VDPWR.n514 868.12125377375
RRED675 VDPWR.n454 VDPWR.n461 4771.660962653
RRED676 VDPWR.n418 VDPWR.n461 52.382664011752
RRED677 VDPWR.n418 VDPWR.n451 1512.1283317341
RRED678 VDPWR.n418 VDPWR.n514 753.7160739299
RRED679 VDPWR.n418 VDPWR.n422 1889.286130451
RRED680 VDPWR.n418 VDPWR.n507 2023.4407648824
RRED681 VDPWR.n418 VDPWR.n511 11911.60313415
RRED682 VDPWR.n418 VDPWR.n460 5101.903421151
RRED683 VDPWR.n461 VDPWR.n460 53.6669900508
RRED684 VDPWR.n461 VDPWR.n514 776.30312548815
RRED685 VDPWR.n461 VDPWR.n451 1649.1929342154
RRED686 VDPWR.n461 VDPWR.n422 3728.188562487
RRED687 VDPWR.n461 VDPWR.n507 1282.8915151902
RRED688 VDPWR.n461 VDPWR.n511 5390.6651876637
RRED689 VDPWR.n460 VDPWR.t5 27.6546
RRED690 VDPWR.n460 VDPWR.n511 2030.9753991958
RRED691 VDPWR.n460 VDPWR.n507 991.95373476238
RRED692 VDPWR.n460 VDPWR.n451 2341.5845715516
RRED693 VDPWR.n511 VDPWR.n413 54.051780571201
RRED694 VDPWR.n511 VDPWR.t5 27.6546
RRED695 VDPWR.n511 VDPWR.n507 963.80031245173
RRED696 VDPWR.n511 VDPWR.n505 8394.9373634214
RRED697 VDPWR.n511 VDPWR.n479 6413.4232217632
RRED698 VDPWR.n511 VDPWR.n514 613.49236174182
RRED699 VDPWR.n511 VDPWR.n451 4063.7709722756
RRED700 VDPWR.n413 VDPWR.n505 53.947972901358
RRED701 VDPWR.n413 VDPWR.n479 2703.801206589
RRED702 VDPWR.n413 VDPWR.n514 653.48447740541
RRED703 VDPWR.n505 VDPWR.n504 54.011224749571
RRED704 VDPWR.n505 VDPWR.n507 506.631748222
RRED705 VDPWR.n505 VDPWR.n479 2040.1060446614
RRED706 VDPWR.n505 VDPWR.n514 983.52660243856
RRED707 VDPWR.n505 VDPWR.n503 8283.1582498586
RRED708 VDPWR.n504 VDPWR.n503 81.540160516049
RRED709 VDPWR.n504 VDPWR.n507 486.26638045244
RRED710 VDPWR.n504 VDPWR.n479 34033.485001633
RRED711 VDPWR.n479 VDPWR.n503 90.159507217469
RRED712 VDPWR.n479 VDPWR.n514 259.01496301046
RRED713 VDPWR.n479 VDPWR.n507 2516.9555554368
RRED714 VDPWR.n503 VDPWR.n507 210.7560605449
RRED715 VDPWR.n507 VDPWR.n451 545.63076944102
RRED716 VDPWR.n451 VDPWR.n422 89.5939990176
RRED717 VDPWR.n451 VDPWR.n514 4800.6428216233
RRED718 VDPWR.n422 VDPWR.n514 400.66583479846
RRED719 VDPWR.n596 VDPWR.n605 52.07515475516
RRED720 VDPWR.n596 VDPWR.n594 163.50401219357
RRED721 VDPWR.n596 VDPWR.n521 4022.0104786608
RRED722 VDPWR.n596 VDPWR.n592 18479.507604658
RRED723 VDPWR.n596 VDPWR.n520 53351.665301177
RRED724 VDPWR.n605 VDPWR.n1 21.7344
RRED725 VDPWR.n605 VDPWR.n520 147.67109364088
RRED726 VDPWR.n520 VDPWR.n587 128.17192738228
RRED727 VDPWR.n520 VDPWR.n592 1371.3154487478
RRED728 VDPWR.n520 VDPWR.n528 2073.388464385
RRED729 VDPWR.n520 VDPWR.n585 9526.3794309582
RRED730 VDPWR.n521 VDPWR.n592 105.01110407785
RRED731 VDPWR.n521 VDPWR.n594 669.33258631297
RRED732 VDPWR.n592 VDPWR.n528 104.32372144677
RRED733 VDPWR.n592 VDPWR.n594 540.1310960668
RRED734 VDPWR.n592 VDPWR.n587 982.1934805296
RRED735 VDPWR.n592 VDPWR.n585 10898.597350584
RRED736 VDPWR.n528 VDPWR.n585 104.76414364359
RRED737 VDPWR.n528 VDPWR.n587 594.2435843762
RRED738 VDPWR.n585 VDPWR.n532 104.32372144677
RRED739 VDPWR.n585 VDPWR.n587 528.40406713884
RRED740 VDPWR.n585 VDPWR.n594 1371.3154487478
RRED741 VDPWR.n585 VDPWR.n581 982.1934805296
RRED742 VDPWR.n585 VDPWR.n579 10898.597350584
RRED743 VDPWR.n587 VDPWR.n575 128.17192738228
RRED744 VDPWR.n587 VDPWR.n579 1371.3154487478
RRED745 VDPWR.n587 VDPWR.n536 2073.388464385
RRED746 VDPWR.n587 VDPWR.n573 9526.3794309582
RRED747 VDPWR.n532 VDPWR.t9 51.3519
RRED748 VDPWR.n532 VDPWR.n581 594.2435843762
RRED749 VDPWR.n532 VDPWR.n579 2622.747049237
RRED750 VDPWR.n532 VDPWR.n594 2073.388464385
RRED751 VDPWR.n579 VDPWR.n536 104.32372144677
RRED752 VDPWR.n579 VDPWR.t9 57.7708
RRED753 VDPWR.n579 VDPWR.n581 528.40406713884
RRED754 VDPWR.n579 VDPWR.n575 982.1934805296
RRED755 VDPWR.n579 VDPWR.n594 9526.3794309582
RRED756 VDPWR.n579 VDPWR.n573 10898.597350584
RRED757 VDPWR.n536 VDPWR.n573 104.76414364359
RRED758 VDPWR.n536 VDPWR.n575 594.2435843762
RRED759 VDPWR.n573 VDPWR.n540 103.55800563936
RRED760 VDPWR.n573 VDPWR.n575 528.40406713884
RRED761 VDPWR.n573 VDPWR.n581 963.48665793495
RRED762 VDPWR.n573 VDPWR.n558 4085.2596612751
RRED763 VDPWR.n573 VDPWR.n567 5387.5350680248
RRED764 VDPWR.n573 VDPWR.n544 11895.387248103
RRED765 VDPWR.n575 VDPWR.n567 905.90244110602
RRED766 VDPWR.n575 VDPWR.n558 711.37596255995
RRED767 VDPWR.n575 VDPWR.n544 886.64504362946
RRED768 VDPWR.n540 VDPWR.n567 102.9097961538
RRED769 VDPWR.n540 VDPWR.n581 991.37727562075
RRED770 VDPWR.n540 VDPWR.n544 5096.7388308824
RRED771 VDPWR.n540 VDPWR.n558 2353.9665642789
RRED772 VDPWR.n567 VDPWR.n544 98.133504411329
RRED773 VDPWR.n567 VDPWR.n558 1294.0693824813
RRED774 VDPWR.n567 VDPWR.n581 1281.5717650931
RRED775 VDPWR.n544 VDPWR.n558 1046.2819579935
RRED776 VDPWR.n544 VDPWR.n581 2019.9569516575
RRED777 VDPWR.n558 VDPWR.n581 548.51599353289
RRED778 VDPWR.n581 VDPWR.n594 128.17192738228
RRED779 VDPWR.n687 VDPWR.n696 52.07515475516
RRED780 VDPWR.n687 VDPWR.n685 163.50401219357
RRED781 VDPWR.n687 VDPWR.n612 4022.0104786608
RRED782 VDPWR.n687 VDPWR.n683 18479.507604658
RRED783 VDPWR.n687 VDPWR.n611 53351.665301177
RRED784 VDPWR.n696 VDPWR.n697 21.7344
RRED785 VDPWR.n696 VDPWR.n611 147.67109364088
RRED786 VDPWR.n611 VDPWR.n678 128.17192738228
RRED787 VDPWR.n611 VDPWR.n683 1371.3154487478
RRED788 VDPWR.n611 VDPWR.n619 2073.388464385
RRED789 VDPWR.n611 VDPWR.n676 9526.3794309582
RRED790 VDPWR.n612 VDPWR.n683 105.01110407785
RRED791 VDPWR.n612 VDPWR.n685 669.33258631297
RRED792 VDPWR.n683 VDPWR.n619 104.32372144677
RRED793 VDPWR.n683 VDPWR.n685 540.1310960668
RRED794 VDPWR.n683 VDPWR.n678 982.1934805296
RRED795 VDPWR.n683 VDPWR.n676 10898.597350584
RRED796 VDPWR.n619 VDPWR.n676 104.76414364359
RRED797 VDPWR.n619 VDPWR.n678 594.2435843762
RRED798 VDPWR.n676 VDPWR.n623 104.32372144677
RRED799 VDPWR.n676 VDPWR.n678 528.40406713884
RRED800 VDPWR.n676 VDPWR.n685 1371.3154487478
RRED801 VDPWR.n676 VDPWR.n672 982.1934805296
RRED802 VDPWR.n676 VDPWR.n670 10898.597350584
RRED803 VDPWR.n678 VDPWR.n666 128.17192738228
RRED804 VDPWR.n678 VDPWR.n670 1371.3154487478
RRED805 VDPWR.n678 VDPWR.n627 2073.388464385
RRED806 VDPWR.n678 VDPWR.n664 9526.3794309582
RRED807 VDPWR.n623 VDPWR.t14 51.3519
RRED808 VDPWR.n623 VDPWR.n672 594.2435843762
RRED809 VDPWR.n623 VDPWR.n670 2622.747049237
RRED810 VDPWR.n623 VDPWR.n685 2073.388464385
RRED811 VDPWR.n670 VDPWR.n627 104.32372144677
RRED812 VDPWR.n670 VDPWR.t14 57.7708
RRED813 VDPWR.n670 VDPWR.n672 528.40406713884
RRED814 VDPWR.n670 VDPWR.n666 982.1934805296
RRED815 VDPWR.n670 VDPWR.n685 9526.3794309582
RRED816 VDPWR.n670 VDPWR.n664 10898.597350584
RRED817 VDPWR.n627 VDPWR.n664 104.76414364359
RRED818 VDPWR.n627 VDPWR.n666 594.2435843762
RRED819 VDPWR.n664 VDPWR.n631 103.55800563936
RRED820 VDPWR.n664 VDPWR.n666 528.40406713884
RRED821 VDPWR.n664 VDPWR.n672 963.48665793495
RRED822 VDPWR.n664 VDPWR.n649 4085.2596612751
RRED823 VDPWR.n664 VDPWR.n658 5387.5350680248
RRED824 VDPWR.n664 VDPWR.n635 11895.387248103
RRED825 VDPWR.n666 VDPWR.n658 905.90244110602
RRED826 VDPWR.n666 VDPWR.n649 711.37596255995
RRED827 VDPWR.n666 VDPWR.n635 886.64504362946
RRED828 VDPWR.n631 VDPWR.n658 102.9097961538
RRED829 VDPWR.n631 VDPWR.n672 991.37727562075
RRED830 VDPWR.n631 VDPWR.n635 5096.7388308824
RRED831 VDPWR.n631 VDPWR.n649 2353.9665642789
RRED832 VDPWR.n658 VDPWR.n635 98.133504411329
RRED833 VDPWR.n658 VDPWR.n649 1294.0693824813
RRED834 VDPWR.n658 VDPWR.n672 1281.5717650931
RRED835 VDPWR.n635 VDPWR.n649 1046.2819579935
RRED836 VDPWR.n635 VDPWR.n672 2019.9569516575
RRED837 VDPWR.n649 VDPWR.n672 548.51599353289
RRED838 VDPWR.n672 VDPWR.n685 128.17192738228
RRED839 VDPWR.n887 VDPWR.n711 18.849206803472
RRED840 VDPWR.n887 VDPWR.n707 12.41330965879
RRED841 VDPWR.n887 VDPWR.n889 525.58327014182
RRED842 VDPWR.n887 VDPWR.n897 840.8755724398
RRED843 VDPWR.n889 VDPWR.n711 159.09281916437
RRED844 VDPWR.n889 VDPWR.n1092 112.79387959289
RRED845 VDPWR.n889 VDPWR.n894 1839.6607448913
RRED846 VDPWR.n889 VDPWR.n707 256647762064.85
RRED847 VDPWR.n889 VDPWR.n897 34853838147.923
RRED848 VDPWR.n707 VDPWR.n894 12.5005
RRED849 VDPWR.n707 VDPWR.n897 875.04346952606
RRED850 VDPWR.n707 VDPWR.n711 2201.5716483227
RRED851 VDPWR.n894 VDPWR.n893 12.5005
RRED852 VDPWR.n894 VDPWR.n1092 1349.992625422
RRED853 VDPWR.n893 VDPWR.t3 6.2505
RRED854 VDPWR.n893 VDPWR.n897 560.89156628032
RRED855 VDPWR.n893 VDPWR.n1089 2670.2022729264
RRED856 VDPWR.n893 VDPWR.n1086 3896.4527708706
RRED857 VDPWR.n893 VDPWR.n702 12268.496929662
RRED858 VDPWR.n1089 VDPWR.n702 12.383286170151
RRED859 VDPWR.n1089 VDPWR.t3 6.2505
RRED860 VDPWR.n1089 VDPWR.n1092 680.08093193919
RRED861 VDPWR.n1089 VDPWR.n942 3195.8046922019
RRED862 VDPWR.n1089 VDPWR.n1086 848.05148542477
RRED863 VDPWR.n1089 VDPWR.n897 848.05148542477
RRED864 VDPWR.n702 VDPWR.n1083 12.5005
RRED865 VDPWR.n702 VDPWR.n1086 560.89156628032
RRED866 VDPWR.n702 VDPWR.n1092 922.30372272001
RRED867 VDPWR.n702 VDPWR.n942 1621.5969115936
RRED868 VDPWR.n702 VDPWR.n897 3896.4527708706
RRED869 VDPWR.n1083 VDPWR.n1082 12.5005
RRED870 VDPWR.n1082 VDPWR.n1081 18.929703816487
RRED871 VDPWR.n1082 VDPWR.n942 525.58325294575
RRED872 VDPWR.n1082 VDPWR.n1086 876.10828977306
RRED873 VDPWR.n942 VDPWR.n1092 109.33046266984
RRED874 VDPWR.n942 VDPWR.n1081 159.0928807093
RRED875 VDPWR.n942 VDPWR.n1086 27520046968.202
RRED876 VDPWR.n1081 VDPWR.n1086 265.19602940415
RRED877 VDPWR.n1086 VDPWR.n897 52.42451922223
RRED878 VDPWR.n897 VDPWR.n711 332.21925116814
RRED879 VDPWR.n0 VDPWR.t8 72.3676
RRED880 VDPWR.n0 VDPWR.n408 21.7344
RRED881 VDPWR.n0 VDPWR.n251 1.5515
RRED882 VDPWR.n0 VDPWR.n1 1.5045
RRED883 VDPWR.n1 VDPWR.t6 72.3676
RRED884 VDPWR.n1 VDPWR.n514 21.7344
RRED885 VDPWR.n1 VDPWR.n697 1.53583
RRED886 VDPWR.n199 VDPWR.n251 1.5515
RRED887 VDPWR.n2 VDPWR 1.3529045156062
RRED888 VGND.n923 VGND.n930 97.273674911244
RRED889 VGND.n923 VGND.n50 30890.880845905
RRED890 VGND.n923 VGND.n723 478439.16732192
RRED891 VGND.n923 VGND.t47 129201.46131978
RRED892 VGND.n923 VGND.t0 554.999067704
RRED893 VGND.n923 VGND.t1 7683.9242173469
RRED894 VGND.n923 VGND.n1 316.9278582052
RRED895 VGND.n923 VGND.t10 12822.497972263
RRED896 VGND.n923 VGND.n798 47658.601609569
RRED897 VGND.n723 VGND.t47 6270.6215656608
RRED898 VGND.n723 VGND.n50 66204.387960733
RRED899 VGND.n723 VGND.t10 27480.78420347
RRED900 VGND.n723 VGND.n1 965.73250671963
RRED901 VGND.n723 VGND.n798 102140.45259393
RRED902 VGND.n723 VGND.n728 274.74325700395
RRED903 VGND.n723 VGND.n676 2267.905920673
RRED904 VGND.n723 VGND.n678 1565.1736575645
RRED905 VGND.n723 VGND.n693 590.2565743022
RRED906 VGND.n723 VGND.t12 331.65045996515
RRED907 VGND.n740 VGND.n742 621.19398379555
RRED908 VGND.n740 VGND.n738 479.32849544512
RRED909 VGND.n740 VGND.n693 761.68603912071
RRED910 VGND.n740 VGND.n674 18214.97331546
RRED911 VGND.n740 VGND.n798 10442.484541578
RRED912 VGND.n740 VGND.n732 6234.7181603666
RRED913 VGND.n740 VGND.n678 10801.787736481
RRED914 VGND.n740 VGND.n676 133530.38472999
RRED915 VGND.n740 VGND.n728 9411.6695431552
RRED916 VGND.t47 VGND.t54 589.41841973276
RRED917 VGND.t47 VGND.n50 17878.351637029
RRED918 VGND.t47 VGND.n0 4006.6079294461
RRED919 VGND.t47 VGND.n1 666.80095548019
RRED920 VGND.t47 VGND.n5 770.85312771953
RRED921 VGND.t47 VGND.t50 179130.79362313
RRED922 VGND.t47 VGND.t45 4013727.2701031
RRED923 VGND.t47 VGND.t10 7421.1262785536
RRED924 VGND.t47 VGND.n798 27582.808090042
RRED925 VGND.n50 VGND.t41 34.852046880798
RRED926 VGND.n50 VGND.n0 322.03552578697
RRED927 VGND.n50 VGND.t42 7208.6622895315
RRED928 VGND.n50 VGND.n930 35507488.594788
RRED929 VGND.n50 VGND.t0 1076425.251391
RRED930 VGND.n50 VGND.t44 219897691.06199
RRED931 VGND.n50 VGND.t10 1774.3230244572
RRED932 VGND.n50 VGND.n1 2835.4865536502
RRED933 VGND.n50 VGND.n798 6594.7956733712
RRED934 VGND.t52 VGND.t45 593.74
RRED935 VGND.t52 VGND.t53 23532.848865329
RRED936 VGND.t52 VGND.n5 370.51020394964
RRED937 VGND.t52 VGND.t48 1248.0873858771
RRED938 VGND.t52 VGND.t49 26214.980255751
RRED939 VGND.t52 VGND.t6 6465.1563054983
RRED940 VGND.t52 VGND.t8 5233.4320667176
RRED941 VGND.t52 VGND 3547.2173089934
RRED942 VGND.n798 VGND.n738 1390.8967677611
RRED943 VGND.n798 VGND.n742 2049.0060319782
RRED944 VGND.n798 VGND.n674 19331.830076607
RRED945 VGND.n798 VGND.t10 193.33458238988
RRED946 VGND.n798 VGND.n1 308.96151005996
RRED947 VGND.n798 VGND.n676 97943.016136524
RRED948 VGND.n798 VGND.n728 6903.3524002858
RRED949 VGND.n798 VGND.n732 383578.0137599
RRED950 VGND.t54 VGND.t45 8031.8114773972
RRED951 VGND.t54 VGND.t50 759.40830500239
RRED952 VGND.t54 VGND.n5 503.1079481308
RRED953 VGND.t54 VGND.n0 6092.8106670118
RRED954 VGND.t54 VGND.n1 1074.4066842808
RRED955 VGND.t45 VGND.t50 759.04522946723
RRED956 VGND.t45 VGND.n5 322.60138118888
RRED957 VGND.t45 VGND.n0 301986.90686303
RRED958 VGND.t45 VGND.n1 53252.393522685
RRED959 VGND.t0 VGND.n930 39.182044092398
RRED960 VGND.t0 VGND.t44 252.93657172082
RRED961 VGND.t0 VGND.n0 1439.3899921435
RRED962 VGND.t0 VGND.t42 515.80262920021
RRED963 VGND.t0 VGND.t41 98021.037868534
RRED964 VGND.t0 VGND.t1 8323.7144404052
RRED965 VGND.t0 VGND.n1 348.70970150176
RRED966 VGND.n930 VGND.t44 8343.4891776978
RRED967 VGND.n930 VGND.n0 47480.420645501
RRED968 VGND.n930 VGND.t42 17014.517217819
RRED969 VGND.n930 VGND.t41 3233369.7854714
RRED970 VGND.n930 VGND.t1 23910.218236067
RRED971 VGND.n930 VGND.n1 1001.6832177072
RRED972 VGND.n728 VGND.n676 373.83061402881
RRED973 VGND.n728 VGND.n674 540.35937039391
RRED974 VGND.n728 VGND.n732 4083.0612504483
RRED975 VGND.n728 VGND.n678 8130.0919039457
RRED976 VGND.n728 VGND.n1 5248.4077948446
RRED977 VGND.n728 VGND.n693 3137.2901022181
RRED978 VGND.n728 VGND.t12 1440.1478495102
RRED979 VGND.n728 VGND.n738 890.27284352195
RRED980 VGND.n728 VGND.n742 930.07205904522
RRED981 VGND.n676 VGND.n678 8124.3177292669
RRED982 VGND.n676 VGND.t12 562.76932617947
RRED983 VGND.n676 VGND.n732 1893.9838382826
RRED984 VGND.n676 VGND.n674 1125.1780513884
RRED985 VGND.n676 VGND.n1 41911.859164498
RRED986 VGND.n676 VGND.n693 25053.24777764
RRED987 VGND.n676 VGND.n738 12630.9657139
RRED988 VGND.n676 VGND.n742 13195.626907794
RRED989 VGND.n732 VGND.t12 25.0005
RRED990 VGND.n732 VGND.n674 743.9110718286
RRED991 VGND.n732 VGND.n738 105.45575596067
RRED992 VGND.n732 VGND.n693 1326.3512619016
RRED993 VGND.n732 VGND.n678 1526.4533535429
RRED994 VGND.n732 VGND.n742 10558.205219151
RRED995 VGND.n674 VGND.n738 538.81408594003
RRED996 VGND.n674 VGND.n742 2966.2402540816
RRED997 VGND.n674 VGND.n693 47048.718975176
RRED998 VGND.n674 VGND.n678 133589.08361092
RRED999 VGND.n738 VGND.n742 403.38798318477
RRED1000 VGND.n738 VGND.n693 1611.9691339398
RRED1001 VGND.n738 VGND.n678 6849.2399950664
RRED1002 VGND.n742 VGND.n693 174.20213405822
RRED1003 VGND.n742 VGND.n678 22715.047020233
RRED1004 VGND.n693 VGND.n1 35.930801168597
RRED1005 VGND.n693 VGND.n678 474.92627450902
RRED1006 VGND.n693 VGND.t12 3094.0038162472
RRED1007 VGND.n678 VGND.t12 551.05683879006
RRED1008 VGND.n678 VGND.n1 1234.2781389924
RRED1009 VGND.t48 VGND.t49 17620.761016014
RRED1010 VGND.t48 VGND.t6 4345.6440965799
RRED1011 VGND.t48 VGND.t8 3517.7236389848
RRED1012 VGND.t48 VGND 2384.3111024251
RRED1013 VGND.t48 VGND.t53 37862.182758729
RRED1014 VGND.t48 VGND.n5 596.11673606518
RRED1015 VGND.t50 VGND.n5 443.57598425789
RRED1016 VGND.t50 VGND.n0 13477.536127854
RRED1017 VGND.t50 VGND.n1 2376.6297189905
RRED1018 VGND.t1 VGND.n1 108.13487183415
RRED1019 VGND.n5 VGND.t46 97.5478
RRED1020 VGND.n5 VGND.t53 120.28008359811
RRED1021 VGND.n5 VGND.n0 57.997849883741
RRED1022 VGND.n5 VGND.n1 10.227345144071
RRED1023 VGND.n5 VGND.t49 158.14796005503
RRED1024 VGND.n5 VGND.t6 39.002557742808
RRED1025 VGND.n5 VGND.t8 31.571895052502
RRED1026 VGND.n5 VGND 21.399412695195
RRED1027 VGND.t53 VGND.t49 10044.722122798
RRED1028 VGND.t53 VGND.t6 2477.2362189721
RRED1029 VGND.t53 VGND.t8 2005.2798188617
RRED1030 VGND.t53 VGND 1359.1775324797
RRED1031 VGND.t49 VGND.t6 1152.886183897
RRED1032 VGND.t49 VGND.t8 933.24140035886
RRED1033 VGND.t49 VGND 632.55049585434
RRED1034 VGND.n0 VGND.t43 92.0364
RRED1035 VGND.n0 VGND.t44 179.07504447116
RRED1036 VGND.n0 VGND.t42 174.37742715686
RRED1037 VGND.n0 VGND.t41 308.75890105522
RRED1038 VGND.n0 VGND.n1 53.157937196986
RRED1039 VGND.n1 VGND.t11 32.8913
RRED1040 VGND.n1 VGND.t13 32.8913
RRED1041 VGND.n1 VGND.t10 257.44002692105
RRED1042 VGND.n1 VGND.t12 5175.9936816139
RRED1043 VGND.t42 VGND.t44 105370.81609546
RRED1044 VGND.t42 VGND.t41 656.4325375594
RRED1045 VGND.t44 VGND.t41 20024242.16167
RRED1046 VGND.t4 VGND 4.28402
RRED1047 VGND.t4 VGND.t2 1.9009207344587
RRED1048 VGND.t4 VGND.t6 4.7093161237982
RRED1049 VGND.t4 VGND.t8 3.3341939221344
RRED1050 VGND.t6 VGND.t8 1.6983326431714
RRED1051 VGND.t6 VGND 10.801250943912
RRED1052 VGND.t6 VGND.t2 3.3341939221344
RRED1053 VGND VGND.t2 3.46784
RRED1054 VGND VGND.t8 8.7434255846932
RRED1055 VGND.t2 VGND.t8 2.3627312982691
RRED1056 MIRROR.n4 MIRROR.n3 121.276
RRED1057 MIRROR.n4 MIRROR 28.3423
RRED1058 MIRROR.n4 MIRROR.n5 6.19208
RRED1059 MIRROR.n3 MIRROR.n2 67.22
RRED1060 MIRROR.n3 MIRROR.t3 48.2005
RRED1061 MIRROR.n8 MIRROR.n7 121.276
RRED1062 MIRROR.n8 MIRROR 28.3423
RRED1063 MIRROR.n8 MIRROR.n9 6.19208
RRED1064 MIRROR.n7 MIRROR.n6 67.22
RRED1065 MIRROR.n7 MIRROR.t0 48.2005
RRED1066 MIRROR.n16 MIRROR.n15 117.434
RRED1067 MIRROR.n16 MIRROR 31.9563
RRED1068 MIRROR.n16 MIRROR.n14 2.51099
RRED1069 MIRROR.n15 MIRROR.t2 7.14175
RRED1070 MIRROR.n15 MIRROR 431.3595688702
RRED1071 MIRROR.n15 MIRROR.n14 129.18407069754
RRED1072 MIRROR.n2 MIRROR.n5 3.97386
RRED1073 MIRROR.n2 MIRROR 3.22741
RRED1074 MIRROR.n6 MIRROR.n9 3.97386
RRED1075 MIRROR.n6 MIRROR 3.22741
RRED1076 MIRROR.n11 MIRROR.n10 37.4189
RRED1077 MIRROR.n11 MIRROR.t1 4.3505
RRED1078 MIRROR.n11 MIRROR 137.74671390223
RRED1079 MIRROR.n11 MIRROR.n13 42.924639996315
RRED1080 MIRROR.n10 MIRROR 31.7518
RRED1081 MIRROR.n10 MIRROR.n13 2.52519
RRED1082 MIRROR MIRROR.n0 12.808
RRED1083 MIRROR MIRROR.n14 7.3563101999372
RRED1084 MIRROR MIRROR.n13 7.4104638616916
RRED1085 MIRROR.n14 MIRROR.n0 15.3507
RRED1086 MIRROR.n0 MIRROR.n13 15.1197
RRED1087 MIRROR.n0 MIRROR.n5 14.8871
RRED1088 MIRROR.n0 MIRROR.n9 14.1194
RRED1089 AMP.n2 AMP.t3 482
RRED1090 AMP.n2 AMP.n1 170.624
RRED1091 AMP.n2 AMP.n3 170.624
RRED1092 AMP.n1 AMP 12.8005
RRED1093 AMP.n1 AMP.n4 10.0806
RRED1094 AMP.n3 AMP 12.8005
RRED1095 AMP.n3 AMP.n4 10.0806
RRED1096 AMP.n15 AMP.n14 117.434
RRED1097 AMP.n15 AMP 31.9563
RRED1098 AMP.n15 AMP.n13 2.51099
RRED1099 AMP.n14 AMP.t0 7.14175
RRED1100 AMP.n14 AMP 431.3595688702
RRED1101 AMP.n14 AMP.n13 129.18407069754
RRED1102 AMP.n11 AMP.n10 61.2913
RRED1103 AMP.n11 AMP 7.04267
RRED1104 AMP.n11 AMP.n12 4.00594
RRED1105 AMP.n10 AMP.t2 56.9009
RRED1106 AMP.n10 AMP 6.17712
RRED1107 AMP.n6 AMP.n5 37.4189
RRED1108 AMP.n6 AMP.t1 4.3505
RRED1109 AMP.n6 AMP 137.74671390223
RRED1110 AMP.n6 AMP.n8 42.924639996315
RRED1111 AMP.n5 AMP 31.7518
RRED1112 AMP.n5 AMP.n8 2.52519
RRED1113 AMP AMP.n13 7.3563101999372
RRED1114 AMP AMP.n8 7.4104638616916
RRED1115 AMP.n13 AMP.n12 15.9757
RRED1116 AMP.n12 AMP.n9 2.33483
RRED1117 AMP.n9 AMP.n8 15.7447
RRED1118 AMP.n9 AMP.n4 14.999
RRED1119 TAIL.n10 TAIL.n9 117.434
RRED1120 TAIL.n10 TAIL 31.9563
RRED1121 TAIL.n10 TAIL.n8 2.51099
RRED1122 TAIL.n9 TAIL.n1 98.1243
RRED1123 TAIL.n9 TAIL.t1 7.14175
RRED1124 TAIL.n3 TAIL.n2 117.434
RRED1125 TAIL.n3 TAIL.n4 98.1243
RRED1126 TAIL.n3 TAIL.t0 7.14175
RRED1127 TAIL.n2 TAIL 31.9563
RRED1128 TAIL.n2 TAIL.n5 2.51099
RRED1129 TAIL.n1 TAIL 5.58763
RRED1130 TAIL.n1 TAIL.n8 1.67339
RRED1131 TAIL.n4 TAIL 5.58763
RRED1132 TAIL.n4 TAIL.n5 1.67339
RRED1133 TAIL TAIL.n0 5.23741
RRED1134 TAIL TAIL.n6 10.2804
RRED1135 TAIL.n0 TAIL.n7 17.184
RRED1136 TAIL.n0 TAIL.t2 60.703
RRED1137 TAIL.n7 TAIL.n8 15.6632
RRED1138 TAIL.n7 TAIL.n6 1.18594
RRED1139 TAIL.n6 TAIL.n5 15.44
RRED1140 HOLD.t0 HOLD 555.04426477084
RRED1141 HOLD.t0 HOLD.n9 324.45008123357
RRED1142 HOLD.t2 HOLD 416.89180534393
RRED1143 HOLD.t2 HOLD.n6 328.30901394086
RRED1144 HOLD.n17 HOLD 5.4523903878831
RRED1145 HOLD.n17 HOLD.n18 5.46925
RRED1146 HOLD HOLD.n13 5.4523903878831
RRED1147 HOLD HOLD.n21 4.5309867206142
RRED1148 HOLD HOLD.n10 4.5309867206142
RRED1149 HOLD HOLD.n19 12.2231
RRED1150 HOLD HOLD.n15 12.2231
RRED1151 HOLD HOLD.n23 7.08874
RRED1152 HOLD HOLD.n22 7.08874
RRED1153 HOLD HOLD.n18 7.08874
RRED1154 HOLD HOLD.n14 7.08874
RRED1155 HOLD HOLD.n12 7.08874
RRED1156 HOLD HOLD.n11 7.08874
RRED1157 HOLD HOLD.n25 2.34267
RRED1158 HOLD HOLD.n26 11.654818563781
RRED1159 HOLD HOLD.t1 134.25754718466
RRED1160 HOLD HOLD.n6 11.618927311748
RRED1161 HOLD HOLD.n9 6.0770867516712
RRED1162 HOLD.n13 HOLD.n14 5.46925
RRED1163 HOLD.t1 HOLD.n26 216.39184366571
RRED1164 HOLD.n11 HOLD.n10 16.5317
RRED1165 HOLD.n11 HOLD.n12 5.46925
RRED1166 HOLD.n22 HOLD.n21 16.5317
RRED1167 HOLD.n22 HOLD.n23 5.46925
RRED1168 HOLD.n26 HOLD.n0 14.1487
RRED1169 HOLD.n0 HOLD.n6 15.3011
RRED1170 HOLD.n0 HOLD.n9 14.5583
RRED1171 HOLD.n0 HOLD.n25 6.75806
RRED1172 HOLD.n25 HOLD.n24 15.223
RRED1173 HOLD.n24 HOLD.n20 6.21925
RRED1174 HOLD.n24 HOLD.n23 4.80362
RRED1175 HOLD.n19 HOLD.n18 11.3661
RRED1176 HOLD.n19 HOLD.n20 4.5005
RRED1177 HOLD.n15 HOLD.n14 11.3661
RRED1178 HOLD.n15 HOLD.n16 4.5005
RRED1179 HOLD.n16 HOLD.n12 11.0224
RRED1180 HOLD.n16 HOLD.n20 6.21925
RRED1181 SAMPLE.t2 SAMPLE 555.04426477084
RRED1182 SAMPLE.t2 SAMPLE.n7 324.45008123357
RRED1183 SAMPLE.t1 SAMPLE 555.04426477084
RRED1184 SAMPLE.t1 SAMPLE.n30 324.45008123357
RRED1185 SAMPLE.t0 SAMPLE 555.04426477084
RRED1186 SAMPLE.t0 SAMPLE.n37 324.45008123357
RRED1187 SAMPLE.n19 SAMPLE 5.3873410966942
RRED1188 SAMPLE.n19 SAMPLE.n20 5.46925
RRED1189 SAMPLE SAMPLE.n8 5.3873410966942
RRED1190 SAMPLE SAMPLE.n15 4.4766867235593
RRED1191 SAMPLE SAMPLE.n11 4.4766867235593
RRED1192 SAMPLE SAMPLE.n21 9.77865
RRED1193 SAMPLE SAMPLE.n10 9.77865
RRED1194 SAMPLE SAMPLE.n20 6.98802
RRED1195 SAMPLE SAMPLE.n17 6.98802
RRED1196 SAMPLE SAMPLE.n16 6.98802
RRED1197 SAMPLE SAMPLE.n13 6.98802
RRED1198 SAMPLE SAMPLE.n12 6.98802
RRED1199 SAMPLE SAMPLE.n9 6.98802
RRED1200 SAMPLE SAMPLE.n23 1.55933
RRED1201 SAMPLE SAMPLE.n27 11.654818563781
RRED1202 SAMPLE SAMPLE.t4 134.25754718466
RRED1203 SAMPLE SAMPLE.n30 6.0770867516712
RRED1204 SAMPLE SAMPLE.n38 11.654818563781
RRED1205 SAMPLE SAMPLE.n34 11.654818563781
RRED1206 SAMPLE SAMPLE.t5 134.25754718466
RRED1207 SAMPLE SAMPLE.n37 6.0770867516712
RRED1208 SAMPLE SAMPLE.t3 134.25754718466
RRED1209 SAMPLE SAMPLE.n7 6.0770867516712
RRED1210 SAMPLE.n8 SAMPLE.n9 5.46925
RRED1211 SAMPLE.t3 SAMPLE.n38 216.39184366571
RRED1212 SAMPLE.t4 SAMPLE.n27 216.39184366571
RRED1213 SAMPLE.t5 SAMPLE.n34 216.39184366571
RRED1214 SAMPLE.n12 SAMPLE.n11 16.5317
RRED1215 SAMPLE.n12 SAMPLE.n13 5.46925
RRED1216 SAMPLE.n16 SAMPLE.n15 16.5317
RRED1217 SAMPLE.n16 SAMPLE.n17 5.46925
RRED1218 SAMPLE.n38 SAMPLE.n2 13.5237
RRED1219 SAMPLE.n27 SAMPLE.n0 13.5237
RRED1220 SAMPLE.n34 SAMPLE.n1 13.5237
RRED1221 SAMPLE.n23 SAMPLE.n22 15.0667
RRED1222 SAMPLE.n23 SAMPLE.n0 3.53594
RRED1223 SAMPLE.n22 SAMPLE.n18 6.21925
RRED1224 SAMPLE.n22 SAMPLE.n21 4.5005
RRED1225 SAMPLE.n2 SAMPLE.n7 14.5965
RRED1226 SAMPLE.n2 SAMPLE.n37 13.9333
RRED1227 SAMPLE.n2 SAMPLE.n1 1.32694
RRED1228 SAMPLE.n1 SAMPLE.n30 13.9333
RRED1229 SAMPLE.n1 SAMPLE.n0 1.53583
RRED1230 SAMPLE.n10 SAMPLE.n9 13.7099
RRED1231 SAMPLE.n10 SAMPLE.n14 10.7193
RRED1232 SAMPLE.n21 SAMPLE.n20 13.7099
RRED1233 SAMPLE.n14 SAMPLE.n13 7.14737
RRED1234 SAMPLE.n14 SAMPLE.n18 6.21925
RRED1235 SAMPLE.n18 SAMPLE.n17 7.14737
RRED1236 S_BAR.n7 S_BAR.t1 407.813
RRED1237 S_BAR.n7 S_BAR 4.62024
RRED1238 S_BAR.n7 S_BAR.n6 2.70094
RRED1239 S_BAR.t1 S_BAR.n1 401.517
RRED1240 S_BAR.n1 S_BAR 21.688
RRED1241 S_BAR.n1 S_BAR.n6 12.6768
RRED1242 S_BAR S_BAR.t2 333.784
RRED1243 S_BAR S_BAR.n0 3.5437055022818
RRED1244 S_BAR S_BAR.n4 13.5534
RRED1245 S_BAR S_BAR.n2 6.33895
RRED1246 S_BAR.n4 S_BAR.n3 197.048
RRED1247 S_BAR.n4 S_BAR.n5 9.32224
RRED1248 S_BAR.n3 S_BAR.n2 92.1489
RRED1249 S_BAR.n3 S_BAR.t0 17.4005
RRED1250 S_BAR.n2 S_BAR.n5 16.0734
RRED1251 S_BAR.n0 S_BAR.n6 12.594
RRED1252 S_BAR.n0 S_BAR.n5 12.5862
RRED1253 L_BAR.n7 L_BAR.t1 407.813
RRED1254 L_BAR.n7 L_BAR 4.62024
RRED1255 L_BAR.n7 L_BAR.n6 2.70094
RRED1256 L_BAR.t1 L_BAR.n1 401.517
RRED1257 L_BAR.n1 L_BAR 21.688
RRED1258 L_BAR.n1 L_BAR.n6 12.6768
RRED1259 L_BAR L_BAR.t2 333.784
RRED1260 L_BAR L_BAR.n0 2.3081548234122
RRED1261 L_BAR L_BAR.n4 13.5534
RRED1262 L_BAR L_BAR.n2 6.33895
RRED1263 L_BAR.n4 L_BAR.n3 197.048
RRED1264 L_BAR.n4 L_BAR.n5 9.32224
RRED1265 L_BAR.n3 L_BAR.n2 92.1489
RRED1266 L_BAR.n3 L_BAR.t0 17.4005
RRED1267 L_BAR.n2 L_BAR.n5 16.0734
RRED1268 L_BAR.n0 L_BAR.n6 12.2815
RRED1269 L_BAR.n0 L_BAR.n5 12.2737
RRED1270 H_BAR.n6 H_BAR.t1 407.813
RRED1271 H_BAR.n6 H_BAR 4.62024
RRED1272 H_BAR.n6 H_BAR.n5 2.70094
RRED1273 H_BAR.t1 H_BAR.n0 401.517
RRED1274 H_BAR.n0 H_BAR 21.688
RRED1275 H_BAR.n0 H_BAR.n5 12.6768
RRED1276 H_BAR H_BAR.t2 333.784
RRED1277 H_BAR H_BAR.n3 13.5534
RRED1278 H_BAR H_BAR.n4 12.7288
RRED1279 H_BAR H_BAR.n5 11.969
RRED1280 H_BAR H_BAR.n1 6.33895
RRED1281 H_BAR.n3 H_BAR.n2 197.048
RRED1282 H_BAR.n3 H_BAR.n4 9.32224
RRED1283 H_BAR.n2 H_BAR.n1 92.1489
RRED1284 H_BAR.n2 H_BAR.t0 17.4005
RRED1285 H_BAR.n1 H_BAR.n4 16.0734
RRED1286 BIAS.n4 BIAS.t3 289.2
RRED1287 BIAS.n4 BIAS.n5 117.15
RRED1288 BIAS.n4 BIAS.n3 65.9614
RRED1289 BIAS.n2 BIAS.n1 117.434
RRED1290 BIAS.n2 BIAS.t2 7.14175
RRED1291 BIAS.n2 BIAS 431.3595688702
RRED1292 BIAS.n2 BIAS.n17 129.18407069754
RRED1293 BIAS.n1 BIAS 31.9563
RRED1294 BIAS.n1 BIAS.n17 2.51099
RRED1295 BIAS.n5 BIAS 28.3694
RRED1296 BIAS.n5 BIAS.n6 6.16394
RRED1297 BIAS.n9 BIAS.n8 117.15
RRED1298 BIAS.n9 BIAS 28.3694
RRED1299 BIAS.n9 BIAS.n10 6.16394
RRED1300 BIAS.n8 BIAS.n7 65.9614
RRED1301 BIAS.n8 BIAS.t4 48.2005
RRED1302 BIAS.n13 BIAS.n12 117.15
RRED1303 BIAS.n13 BIAS 28.3694
RRED1304 BIAS.n13 BIAS.n14 6.16394
RRED1305 BIAS.n12 BIAS.n11 65.9614
RRED1306 BIAS.n12 BIAS.t1 48.2005
RRED1307 BIAS.n3 BIAS.n6 3.92068
RRED1308 BIAS.n3 BIAS 3.27839
RRED1309 BIAS.n7 BIAS.n10 3.92068
RRED1310 BIAS.n7 BIAS 3.27839
RRED1311 BIAS.n11 BIAS.n14 3.92068
RRED1312 BIAS.n11 BIAS 3.27839
RRED1313 BIAS.n15 BIAS.t0 56.9009
RRED1314 BIAS.n15 BIAS.n16 55.5762
RRED1315 BIAS.n15 BIAS 6.17712
RRED1316 BIAS.n16 BIAS 5.476
RRED1317 BIAS.n16 BIAS.n0 4.96683
RRED1318 BIAS BIAS.n17 7.3563101999372
RRED1319 BIAS.n0 BIAS.n6 14.58
RRED1320 BIAS.n0 BIAS.n17 14.5025
RRED1321 BIAS.n0 BIAS.n10 13.4881
RRED1322 BIAS.n0 BIAS.n14 13.4881
.ends
