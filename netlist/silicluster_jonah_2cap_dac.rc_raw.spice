* PEX produced on Fri Oct  2 10:10:21 PM CEST 2026 using /foss/tools/sak/sak-pex.sh with m=3 and s=1 (extresist threshold=1000 mOhm, minres=1000 mOhm, mindelay=0 ps)
* NGSPICE file created from silicluster_jonah_2cap_dac_pex.ext - technology: sky130A

.subckt silicluster_jonah_2cap_dac_pex VGND VDPWR charge_high charge_low share vref_high
+ vref_low vout
X0 VDPWR.t13 charge_high.t1 H_BAR.t1 VDPWR.t12 sky130_fd_pr__pfet_01v8 ad=0.58 pd=4.58 as=0.58 ps=4.58 w=2 l=0.15
X1 VGND.t53 charge_low.t2 L_BAR.t0 VGND.t52 sky130_fd_pr__nfet_01v8 ad=0.29 pd=2.58 as=0.29 ps=2.58 w=1 l=0.15
X2 SAMPLE.t5 charge_low.t0 vref_low.t1 VGND.t54 sky130_fd_pr__nfet_01v8 ad=0.29 pd=2.58 as=0.29 ps=2.58 w=1 l=0.15
X3 HOLD VGND.t6 sky130_fd_pr__cap_mim_m3_1 l=14 w=14
X4 HOLD VGND.t4 sky130_fd_pr__cap_mim_m3_1 l=14 w=14
X5 SAMPLE VGND.t4 sky130_fd_pr__cap_mim_m3_1 l=14 w=14
X6 SAMPLE VGND.t6 sky130_fd_pr__cap_mim_m3_1 l=14 w=14
X7 SAMPLE VGND.t8 sky130_fd_pr__cap_mim_m3_1 l=14 w=14
X8 SAMPLE VGND.t2 sky130_fd_pr__cap_mim_m3_1 l=14 w=14
X9 VGND.t49 charge_high.t2 H_BAR.t0 VGND.t48 sky130_fd_pr__nfet_01v8 ad=0.29 pd=2.58 as=0.29 ps=2.58 w=1 l=0.15
X10 SAMPLE.t4 charge_high.t0 vref_high.t1 VGND.t50 sky130_fd_pr__nfet_01v8 ad=0.29 pd=2.58 as=0.29 ps=2.58 w=1 l=0.15
X11 HOLD VGND.t2 sky130_fd_pr__cap_mim_m3_1 l=14 w=14
X12 VGND.t11 MIRROR.t3 AMP.t1 VGND.t10 sky130_fd_pr__nfet_01v8 ad=1.16 pd=8.58 as=1.16 ps=8.58 w=4 l=2
X13 HOLD VGND.t2 sky130_fd_pr__cap_mim_m3_1 l=14 w=14
X14 TAIL.t2 vout.t4 MIRROR.t2 VDPWR.t14 sky130_fd_pr__pfet_01v8_lvt ad=1.16 pd=8.58 as=1.16 ps=8.58 w=4 l=1
X15 SAMPLE VGND.t2 sky130_fd_pr__cap_mim_m3_1 l=14 w=14
X16 HOLD VGND.t6 sky130_fd_pr__cap_mim_m3_1 l=14 w=14
X17 SAMPLE VGND.t2 sky130_fd_pr__cap_mim_m3_1 l=14 w=14
X18 HOLD VGND.t4 sky130_fd_pr__cap_mim_m3_1 l=14 w=14
X19 HOLD.t0 S_BAR.t2 SAMPLE.t2 VDPWR.t2 sky130_fd_pr__pfet_01v8_lvt ad=0.58 pd=4.58 as=0.58 ps=4.58 w=2 l=0.35
X20 HOLD VGND.t8 sky130_fd_pr__cap_mim_m3_1 l=14 w=14
X21 SAMPLE VGND.t4 sky130_fd_pr__cap_mim_m3_1 l=14 w=14
X22 VDPWR.t6 BIAS.t4 TAIL.t0 VDPWR.t5 sky130_fd_pr__pfet_01v8 ad=1.16 pd=8.58 as=1.16 ps=8.58 w=4 l=2
X23 HOLD VGND.t6 sky130_fd_pr__cap_mim_m3_1 l=14 w=14
X24 HOLD VGND.t6 sky130_fd_pr__cap_mim_m3_1 l=14 w=14
X25 SAMPLE VGND.t8 sky130_fd_pr__cap_mim_m3_1 l=14 w=14
X26 HOLD VGND.t8 sky130_fd_pr__cap_mim_m3_1 l=14 w=14
X27 SAMPLE.t0 L_BAR.t2 vref_low.t0 VDPWR.t0 sky130_fd_pr__pfet_01v8_lvt ad=0.58 pd=4.58 as=0.58 ps=4.58 w=2 l=0.35
X28 VDPWR.t8 BIAS.t1 BIAS.t2 VDPWR.t7 sky130_fd_pr__pfet_01v8 ad=1.16 pd=8.58 as=1.16 ps=8.58 w=4 l=2
X29 AMP.t2 COMP VGND.t44 sky130_fd_pr__res_xhigh_po_0p35 l=14
X30 SAMPLE VGND.t4 sky130_fd_pr__cap_mim_m3_1 l=14 w=14
X31 RBMID VGND.t43 VGND.t42 sky130_fd_pr__res_xhigh_po_0p35 l=30
X32 SAMPLE.t1 H_BAR.t2 vref_high.t0 VDPWR.t1 sky130_fd_pr__pfet_01v8_lvt ad=0.58 pd=4.58 as=0.58 ps=4.58 w=2 l=0.35
X33 BIAS.t0 RBMID VGND.t41 sky130_fd_pr__res_xhigh_po_0p35 l=30
X34 HOLD VGND.t4 sky130_fd_pr__cap_mim_m3_1 l=14 w=14
X35 SAMPLE VGND.t6 sky130_fd_pr__cap_mim_m3_1 l=14 w=14
X36 HOLD VGND.t4 sky130_fd_pr__cap_mim_m3_1 l=14 w=14
X37 VGND.t13 MIRROR.t0 MIRROR.t1 VGND.t12 sky130_fd_pr__nfet_01v8 ad=1.16 pd=8.58 as=1.16 ps=8.58 w=4 l=2
X38 VGND.t1 AMP.t3 vout.t0 VGND.t0 sky130_fd_pr__nfet_01v8 ad=5.8 pd=40.58 as=5.8 ps=40.58 w=20 l=1
X39 COMP vout.t2 sky130_fd_pr__cap_mim_m3_1 l=26 w=26
X40 HOLD VGND.t2 sky130_fd_pr__cap_mim_m3_1 l=14 w=14
X41 TAIL.t1 HOLD.t2 AMP.t0 VDPWR.t9 sky130_fd_pr__pfet_01v8_lvt ad=1.16 pd=8.58 as=1.16 ps=8.58 w=4 l=1
X42 SAMPLE VGND.t6 sky130_fd_pr__cap_mim_m3_1 l=14 w=14
X43 SAMPLE VGND.t2 sky130_fd_pr__cap_mim_m3_1 l=14 w=14
X44 HOLD VGND.t2 sky130_fd_pr__cap_mim_m3_1 l=14 w=14
X45 HOLD VGND.t8 sky130_fd_pr__cap_mim_m3_1 l=14 w=14
X46 SAMPLE VGND.t8 sky130_fd_pr__cap_mim_m3_1 l=14 w=14
X47 SAMPLE VGND.t6 sky130_fd_pr__cap_mim_m3_1 l=14 w=14
X48 HOLD VGND.t8 sky130_fd_pr__cap_mim_m3_1 l=14 w=14
X49 VDPWR.t11 share.t1 S_BAR.t1 VDPWR.t10 sky130_fd_pr__pfet_01v8 ad=0.58 pd=4.58 as=0.58 ps=4.58 w=2 l=0.15
X50 VDPWR.t4 BIAS.t3 vout.t1 VDPWR.t3 sky130_fd_pr__pfet_01v8 ad=6.96 pd=48.58 as=6.96 ps=48.58 w=24 l=2
X51 VDPWR.t16 charge_low.t1 L_BAR.t1 VDPWR.t15 sky130_fd_pr__pfet_01v8 ad=0.58 pd=4.58 as=0.58 ps=4.58 w=2 l=0.15
X52 VGND.t46 share.t2 S_BAR.t0 VGND.t45 sky130_fd_pr__nfet_01v8 ad=0.29 pd=2.58 as=0.29 ps=2.58 w=1 l=0.15
X53 HOLD.t1 share.t0 SAMPLE.t3 VGND.t47 sky130_fd_pr__nfet_01v8 ad=0.29 pd=2.58 as=0.29 ps=2.58 w=1 l=0.15
X54 SAMPLE VGND.t8 sky130_fd_pr__cap_mim_m3_1 l=14 w=14
X55 SAMPLE VGND.t4 sky130_fd_pr__cap_mim_m3_1 l=14 w=14
R0 vout.n0 vout.t1 209.708
R1 vout.n1 vout.t4 201.232
R2 vout.n0 vout.t0 108.117
R3 vout vout.n2 58.7347
R4 vout.n2 vout.t2 48.0425
R5 vout.n2 vout.n1 23.729
R6 vout.n1 vout.n0 3.37928
R7 vref_low.n0 vref_low.t0 219.865
R8 vref_low.n0 vref_low.t1 100.361
R9 vref_low vref_low.n0 62.6061
R10 vref_high.n0 vref_high.t0 219.553
R11 vref_high.n0 vref_high.t1 100.047
R12 vref_high vref_high.n0 62.2936
R13 share.n0 share.t1 567.529
R14 share.n0 share.t0 396.466
R15 share.n0 share.t2 393.07
R16 share share.n0 14.502
R17 charge_low.n0 charge_low.t1 567.216
R18 charge_low.n0 charge_low.t0 396.152
R19 charge_low.n0 charge_low.t2 392.759
R20 charge_low charge_low.n0 14.1895
R21 charge_high.n0 charge_high.t1 566.904
R22 charge_high.n0 charge_high.t0 395.841
R23 charge_high.n0 charge_high.t2 392.445
R24 charge_high charge_high.n0 13.877
R25 VDPWR.n27 VDPWR.n8 825.883
R26 VDPWR.n50 VDPWR.n9 825.883
R27 VDPWR.n48 VDPWR.n12 825.883
R28 VDPWR.n30 VDPWR.n11 825.883
R29 VDPWR.n75 VDPWR.n56 825.883
R30 VDPWR.n98 VDPWR.n57 825.883
R31 VDPWR.n96 VDPWR.n60 825.883
R32 VDPWR.n78 VDPWR.n59 825.883
R33 VDPWR.n122 VDPWR.n103 825.883
R34 VDPWR.n145 VDPWR.n104 825.883
R35 VDPWR.n143 VDPWR.n107 825.883
R36 VDPWR.n125 VDPWR.n106 825.883
R37 VDPWR.n193 VDPWR.n156 776.471
R38 VDPWR.n196 VDPWR.n195 776.471
R39 VDPWR.n174 VDPWR.n168 776.471
R40 VDPWR.n176 VDPWR.n166 776.471
R41 VDPWR.n245 VDPWR.n208 776.471
R42 VDPWR.n248 VDPWR.n247 776.471
R43 VDPWR.n226 VDPWR.n220 776.471
R44 VDPWR.n228 VDPWR.n218 776.471
R45 VDPWR.n297 VDPWR.n260 776.471
R46 VDPWR.n300 VDPWR.n299 776.471
R47 VDPWR.n278 VDPWR.n272 776.471
R48 VDPWR.n280 VDPWR.n270 776.471
R49 VDPWR.n598 VDPWR.n525 751.765
R50 VDPWR.n601 VDPWR.n600 751.765
R51 VDPWR.n562 VDPWR.n547 751.765
R52 VDPWR.n560 VDPWR.n549 751.765
R53 VDPWR.n689 VDPWR.n616 751.765
R54 VDPWR.n692 VDPWR.n691 751.765
R55 VDPWR.n653 VDPWR.n638 751.765
R56 VDPWR.n651 VDPWR.n640 751.765
R57 VDPWR.n349 VDPWR.n315 744.707
R58 VDPWR.n372 VDPWR.n362 744.707
R59 VDPWR.n395 VDPWR.n360 744.707
R60 VDPWR.n347 VDPWR.n317 744.707
R61 VDPWR.n455 VDPWR.n421 744.707
R62 VDPWR.n478 VDPWR.n468 744.707
R63 VDPWR.n501 VDPWR.n466 744.707
R64 VDPWR.n453 VDPWR.n423 744.707
R65 VDPWR.n888 VDPWR.n710 723.529
R66 VDPWR.n943 VDPWR.n901 723.529
R67 VDPWR.n1079 VDPWR.n899 723.529
R68 VDPWR.n886 VDPWR.n712 723.529
R69 VDPWR.n194 VDPWR.n154 261.147
R70 VDPWR.n175 VDPWR.n167 261.147
R71 VDPWR.n246 VDPWR.n206 261.147
R72 VDPWR.n227 VDPWR.n219 261.147
R73 VDPWR.n298 VDPWR.n258 261.147
R74 VDPWR.n279 VDPWR.n271 261.147
R75 VDPWR.n27 VDPWR.n18 240
R76 VDPWR.n23 VDPWR.n22 240
R77 VDPWR.n19 VDPWR.n14 240
R78 VDPWR.n50 VDPWR.n8 240
R79 VDPWR.n38 VDPWR.n37 240
R80 VDPWR.n42 VDPWR.n41 240
R81 VDPWR.n44 VDPWR.n42 240
R82 VDPWR.n48 VDPWR.n11 240
R83 VDPWR.n75 VDPWR.n66 240
R84 VDPWR.n71 VDPWR.n70 240
R85 VDPWR.n67 VDPWR.n62 240
R86 VDPWR.n98 VDPWR.n56 240
R87 VDPWR.n86 VDPWR.n85 240
R88 VDPWR.n90 VDPWR.n89 240
R89 VDPWR.n92 VDPWR.n90 240
R90 VDPWR.n96 VDPWR.n59 240
R91 VDPWR.n122 VDPWR.n113 240
R92 VDPWR.n118 VDPWR.n117 240
R93 VDPWR.n114 VDPWR.n109 240
R94 VDPWR.n145 VDPWR.n103 240
R95 VDPWR.n133 VDPWR.n132 240
R96 VDPWR.n137 VDPWR.n136 240
R97 VDPWR.n139 VDPWR.n137 240
R98 VDPWR.n143 VDPWR.n106 240
R99 VDPWR.n193 VDPWR.n155 240
R100 VDPWR.n189 VDPWR.n155 240
R101 VDPWR.n189 VDPWR.n158 240
R102 VDPWR.n180 VDPWR.n158 240
R103 VDPWR.n180 VDPWR.n164 240
R104 VDPWR.n176 VDPWR.n164 240
R105 VDPWR.n156 VDPWR.n149 240
R106 VDPWR.n195 VDPWR.n152 240
R107 VDPWR.n187 VDPWR.n152 240
R108 VDPWR.n187 VDPWR.n159 240
R109 VDPWR.n182 VDPWR.n159 240
R110 VDPWR.n182 VDPWR.n161 240
R111 VDPWR.n174 VDPWR.n161 240
R112 VDPWR.n170 VDPWR.n168 240
R113 VDPWR.n245 VDPWR.n207 240
R114 VDPWR.n241 VDPWR.n207 240
R115 VDPWR.n241 VDPWR.n210 240
R116 VDPWR.n232 VDPWR.n210 240
R117 VDPWR.n232 VDPWR.n216 240
R118 VDPWR.n228 VDPWR.n216 240
R119 VDPWR.n208 VDPWR.n201 240
R120 VDPWR.n247 VDPWR.n204 240
R121 VDPWR.n239 VDPWR.n204 240
R122 VDPWR.n239 VDPWR.n211 240
R123 VDPWR.n234 VDPWR.n211 240
R124 VDPWR.n234 VDPWR.n213 240
R125 VDPWR.n226 VDPWR.n213 240
R126 VDPWR.n222 VDPWR.n220 240
R127 VDPWR.n297 VDPWR.n259 240
R128 VDPWR.n293 VDPWR.n259 240
R129 VDPWR.n293 VDPWR.n262 240
R130 VDPWR.n284 VDPWR.n262 240
R131 VDPWR.n284 VDPWR.n268 240
R132 VDPWR.n280 VDPWR.n268 240
R133 VDPWR.n260 VDPWR.n253 240
R134 VDPWR.n299 VDPWR.n256 240
R135 VDPWR.n291 VDPWR.n256 240
R136 VDPWR.n291 VDPWR.n263 240
R137 VDPWR.n286 VDPWR.n263 240
R138 VDPWR.n286 VDPWR.n265 240
R139 VDPWR.n278 VDPWR.n265 240
R140 VDPWR.n274 VDPWR.n272 240
R141 VDPWR.n328 VDPWR.n327 240
R142 VDPWR.n329 VDPWR.n328 240
R143 VDPWR.n333 VDPWR.n322 240
R144 VDPWR.n336 VDPWR.n335 240
R145 VDPWR.n340 VDPWR.n319 240
R146 VDPWR.n341 VDPWR.n340 240
R147 VDPWR.n343 VDPWR.n317 240
R148 VDPWR.n362 VDPWR.n361 240
R149 VDPWR.n361 VDPWR.n306 240
R150 VDPWR.n406 VDPWR.n306 240
R151 VDPWR.n406 VDPWR.n305 240
R152 VDPWR.n353 VDPWR.n305 240
R153 VDPWR.n353 VDPWR.n313 240
R154 VDPWR.n349 VDPWR.n313 240
R155 VDPWR.n376 VDPWR.n375 240
R156 VDPWR.n380 VDPWR.n379 240
R157 VDPWR.n382 VDPWR.n368 240
R158 VDPWR.n385 VDPWR.n368 240
R159 VDPWR.n389 VDPWR.n388 240
R160 VDPWR.n391 VDPWR.n369 240
R161 VDPWR.n400 VDPWR.n360 240
R162 VDPWR.n400 VDPWR.n309 240
R163 VDPWR.n404 VDPWR.n309 240
R164 VDPWR.n404 VDPWR.n308 240
R165 VDPWR.n356 VDPWR.n308 240
R166 VDPWR.n356 VDPWR.n311 240
R167 VDPWR.n347 VDPWR.n311 240
R168 VDPWR.n433 VDPWR.n421 240
R169 VDPWR.n437 VDPWR.n431 240
R170 VDPWR.n440 VDPWR.n439 240
R171 VDPWR.n441 VDPWR.n440 240
R172 VDPWR.n445 VDPWR.n427 240
R173 VDPWR.n448 VDPWR.n447 240
R174 VDPWR.n449 VDPWR.n448 240
R175 VDPWR.n468 VDPWR.n467 240
R176 VDPWR.n467 VDPWR.n412 240
R177 VDPWR.n512 VDPWR.n412 240
R178 VDPWR.n512 VDPWR.n411 240
R179 VDPWR.n459 VDPWR.n411 240
R180 VDPWR.n459 VDPWR.n419 240
R181 VDPWR.n455 VDPWR.n419 240
R182 VDPWR.n480 VDPWR.n473 240
R183 VDPWR.n483 VDPWR.n473 240
R184 VDPWR.n487 VDPWR.n486 240
R185 VDPWR.n491 VDPWR.n490 240
R186 VDPWR.n495 VDPWR.n494 240
R187 VDPWR.n497 VDPWR.n475 240
R188 VDPWR.n506 VDPWR.n466 240
R189 VDPWR.n506 VDPWR.n415 240
R190 VDPWR.n510 VDPWR.n415 240
R191 VDPWR.n510 VDPWR.n414 240
R192 VDPWR.n462 VDPWR.n414 240
R193 VDPWR.n462 VDPWR.n417 240
R194 VDPWR.n453 VDPWR.n417 240
R195 VDPWR.n598 VDPWR.n522 240
R196 VDPWR.n593 VDPWR.n522 240
R197 VDPWR.n593 VDPWR.n527 240
R198 VDPWR.n584 VDPWR.n527 240
R199 VDPWR.n584 VDPWR.n533 240
R200 VDPWR.n580 VDPWR.n533 240
R201 VDPWR.n580 VDPWR.n535 240
R202 VDPWR.n572 VDPWR.n535 240
R203 VDPWR.n572 VDPWR.n541 240
R204 VDPWR.n568 VDPWR.n541 240
R205 VDPWR.n568 VDPWR.n543 240
R206 VDPWR.n560 VDPWR.n543 240
R207 VDPWR.n603 VDPWR.n516 240
R208 VDPWR.n525 VDPWR.n524 240
R209 VDPWR.n600 VDPWR.n519 240
R210 VDPWR.n591 VDPWR.n519 240
R211 VDPWR.n591 VDPWR.n529 240
R212 VDPWR.n586 VDPWR.n529 240
R213 VDPWR.n586 VDPWR.n531 240
R214 VDPWR.n578 VDPWR.n531 240
R215 VDPWR.n578 VDPWR.n537 240
R216 VDPWR.n574 VDPWR.n537 240
R217 VDPWR.n574 VDPWR.n539 240
R218 VDPWR.n566 VDPWR.n539 240
R219 VDPWR.n566 VDPWR.n545 240
R220 VDPWR.n562 VDPWR.n545 240
R221 VDPWR.n554 VDPWR.n553 240
R222 VDPWR.n556 VDPWR.n554 240
R223 VDPWR.n689 VDPWR.n613 240
R224 VDPWR.n684 VDPWR.n613 240
R225 VDPWR.n684 VDPWR.n618 240
R226 VDPWR.n675 VDPWR.n618 240
R227 VDPWR.n675 VDPWR.n624 240
R228 VDPWR.n671 VDPWR.n624 240
R229 VDPWR.n671 VDPWR.n626 240
R230 VDPWR.n663 VDPWR.n626 240
R231 VDPWR.n663 VDPWR.n632 240
R232 VDPWR.n659 VDPWR.n632 240
R233 VDPWR.n659 VDPWR.n634 240
R234 VDPWR.n651 VDPWR.n634 240
R235 VDPWR.n694 VDPWR.n607 240
R236 VDPWR.n616 VDPWR.n615 240
R237 VDPWR.n691 VDPWR.n610 240
R238 VDPWR.n682 VDPWR.n610 240
R239 VDPWR.n682 VDPWR.n620 240
R240 VDPWR.n677 VDPWR.n620 240
R241 VDPWR.n677 VDPWR.n622 240
R242 VDPWR.n669 VDPWR.n622 240
R243 VDPWR.n669 VDPWR.n628 240
R244 VDPWR.n665 VDPWR.n628 240
R245 VDPWR.n665 VDPWR.n630 240
R246 VDPWR.n657 VDPWR.n630 240
R247 VDPWR.n657 VDPWR.n636 240
R248 VDPWR.n653 VDPWR.n636 240
R249 VDPWR.n645 VDPWR.n644 240
R250 VDPWR.n647 VDPWR.n645 240
R251 VDPWR.n765 VDPWR.n764 240
R252 VDPWR.n766 VDPWR.n765 240
R253 VDPWR.n770 VDPWR.n759 240
R254 VDPWR.n773 VDPWR.n772 240
R255 VDPWR.n775 VDPWR.n756 240
R256 VDPWR.n779 VDPWR.n756 240
R257 VDPWR.n782 VDPWR.n781 240
R258 VDPWR.n783 VDPWR.n782 240
R259 VDPWR.n787 VDPWR.n752 240
R260 VDPWR.n790 VDPWR.n789 240
R261 VDPWR.n794 VDPWR.n749 240
R262 VDPWR.n797 VDPWR.n796 240
R263 VDPWR.n801 VDPWR.n746 240
R264 VDPWR.n804 VDPWR.n803 240
R265 VDPWR.n808 VDPWR.n743 240
R266 VDPWR.n811 VDPWR.n810 240
R267 VDPWR.n812 VDPWR.n811 240
R268 VDPWR.n816 VDPWR.n739 240
R269 VDPWR.n819 VDPWR.n818 240
R270 VDPWR.n823 VDPWR.n736 240
R271 VDPWR.n826 VDPWR.n825 240
R272 VDPWR.n828 VDPWR.n733 240
R273 VDPWR.n832 VDPWR.n733 240
R274 VDPWR.n835 VDPWR.n834 240
R275 VDPWR.n836 VDPWR.n835 240
R276 VDPWR.n840 VDPWR.n729 240
R277 VDPWR.n843 VDPWR.n842 240
R278 VDPWR.n847 VDPWR.n726 240
R279 VDPWR.n848 VDPWR.n847 240
R280 VDPWR.n850 VDPWR.n724 240
R281 VDPWR.n854 VDPWR.n724 240
R282 VDPWR.n857 VDPWR.n856 240
R283 VDPWR.n861 VDPWR.n721 240
R284 VDPWR.n864 VDPWR.n863 240
R285 VDPWR.n866 VDPWR.n718 240
R286 VDPWR.n870 VDPWR.n718 240
R287 VDPWR.n873 VDPWR.n872 240
R288 VDPWR.n875 VDPWR.n715 240
R289 VDPWR.n879 VDPWR.n715 240
R290 VDPWR.n882 VDPWR.n881 240
R291 VDPWR.n901 VDPWR.n900 240
R292 VDPWR.n900 VDPWR.n701 240
R293 VDPWR.n1090 VDPWR.n701 240
R294 VDPWR.n1090 VDPWR.n700 240
R295 VDPWR.n892 VDPWR.n700 240
R296 VDPWR.n892 VDPWR.n708 240
R297 VDPWR.n888 VDPWR.n708 240
R298 VDPWR.n947 VDPWR.n946 240
R299 VDPWR.n951 VDPWR.n950 240
R300 VDPWR.n955 VDPWR.n954 240
R301 VDPWR.n957 VDPWR.n918 240
R302 VDPWR.n960 VDPWR.n918 240
R303 VDPWR.n964 VDPWR.n963 240
R304 VDPWR.n966 VDPWR.n924 240
R305 VDPWR.n969 VDPWR.n924 240
R306 VDPWR.n973 VDPWR.n972 240
R307 VDPWR.n977 VDPWR.n976 240
R308 VDPWR.n981 VDPWR.n980 240
R309 VDPWR.n985 VDPWR.n984 240
R310 VDPWR.n989 VDPWR.n988 240
R311 VDPWR.n991 VDPWR.n912 240
R312 VDPWR.n994 VDPWR.n912 240
R313 VDPWR.n998 VDPWR.n997 240
R314 VDPWR.n1002 VDPWR.n1001 240
R315 VDPWR.n1006 VDPWR.n1005 240
R316 VDPWR.n1010 VDPWR.n1009 240
R317 VDPWR.n1012 VDPWR.n932 240
R318 VDPWR.n1015 VDPWR.n932 240
R319 VDPWR.n1019 VDPWR.n1018 240
R320 VDPWR.n1023 VDPWR.n1022 240
R321 VDPWR.n1027 VDPWR.n1026 240
R322 VDPWR.n1031 VDPWR.n1030 240
R323 VDPWR.n1035 VDPWR.n1034 240
R324 VDPWR.n1039 VDPWR.n1038 240
R325 VDPWR.n1043 VDPWR.n1042 240
R326 VDPWR.n1045 VDPWR.n905 240
R327 VDPWR.n1048 VDPWR.n905 240
R328 VDPWR.n1052 VDPWR.n1051 240
R329 VDPWR.n1056 VDPWR.n1055 240
R330 VDPWR.n1060 VDPWR.n1059 240
R331 VDPWR.n1062 VDPWR.n938 240
R332 VDPWR.n1065 VDPWR.n938 240
R333 VDPWR.n1069 VDPWR.n1068 240
R334 VDPWR.n1073 VDPWR.n1072 240
R335 VDPWR.n1075 VDPWR.n940 240
R336 VDPWR.n1084 VDPWR.n899 240
R337 VDPWR.n1084 VDPWR.n704 240
R338 VDPWR.n1088 VDPWR.n704 240
R339 VDPWR.n1088 VDPWR.n703 240
R340 VDPWR.n895 VDPWR.n703 240
R341 VDPWR.n895 VDPWR.n706 240
R342 VDPWR.n886 VDPWR.n706 240
R343 VDPWR.n53 VDPWR.t13 216.494
R344 VDPWR.n4 VDPWR.t16 216.3
R345 VDPWR.n3 VDPWR.t11 216.3
R346 VDPWR.n5 VDPWR.t4 204.083
R347 VDPWR.n599 VDPWR.n518 197.382
R348 VDPWR.n561 VDPWR.n548 197.382
R349 VDPWR.n690 VDPWR.n609 197.382
R350 VDPWR.n652 VDPWR.n639 197.382
R351 VDPWR.n17 VDPWR.n8 185
R352 VDPWR.n8 VDPWR.n6 185
R353 VDPWR.n50 VDPWR.n49 185
R354 VDPWR.n51 VDPWR.n50 185
R355 VDPWR.n9 VDPWR.n7 185
R356 VDPWR.n37 VDPWR.n35 185
R357 VDPWR.n39 VDPWR.n38 185
R358 VDPWR.n41 VDPWR.n40 185
R359 VDPWR.n42 VDPWR.n10 185
R360 VDPWR.n42 VDPWR.n33 185
R361 VDPWR.n45 VDPWR.n44 185
R362 VDPWR.n46 VDPWR.n12 185
R363 VDPWR.n49 VDPWR.n48 185
R364 VDPWR.n48 VDPWR.n47 185
R365 VDPWR.n17 VDPWR.n11 185
R366 VDPWR.n32 VDPWR.n11 185
R367 VDPWR.n31 VDPWR.n30 185
R368 VDPWR.n14 VDPWR.n13 185
R369 VDPWR.n20 VDPWR.n19 185
R370 VDPWR.n22 VDPWR.n21 185
R371 VDPWR.n24 VDPWR.n23 185
R372 VDPWR.n25 VDPWR.n18 185
R373 VDPWR.n28 VDPWR.n27 185
R374 VDPWR.n27 VDPWR.n26 185
R375 VDPWR.n65 VDPWR.n56 185
R376 VDPWR.n56 VDPWR.n54 185
R377 VDPWR.n98 VDPWR.n97 185
R378 VDPWR.n99 VDPWR.n98 185
R379 VDPWR.n57 VDPWR.n55 185
R380 VDPWR.n85 VDPWR.n83 185
R381 VDPWR.n87 VDPWR.n86 185
R382 VDPWR.n89 VDPWR.n88 185
R383 VDPWR.n90 VDPWR.n58 185
R384 VDPWR.n90 VDPWR.n81 185
R385 VDPWR.n93 VDPWR.n92 185
R386 VDPWR.n94 VDPWR.n60 185
R387 VDPWR.n97 VDPWR.n96 185
R388 VDPWR.n96 VDPWR.n95 185
R389 VDPWR.n65 VDPWR.n59 185
R390 VDPWR.n80 VDPWR.n59 185
R391 VDPWR.n79 VDPWR.n78 185
R392 VDPWR.n62 VDPWR.n61 185
R393 VDPWR.n68 VDPWR.n67 185
R394 VDPWR.n70 VDPWR.n69 185
R395 VDPWR.n72 VDPWR.n71 185
R396 VDPWR.n73 VDPWR.n66 185
R397 VDPWR.n76 VDPWR.n75 185
R398 VDPWR.n75 VDPWR.n74 185
R399 VDPWR.n112 VDPWR.n103 185
R400 VDPWR.n103 VDPWR.n101 185
R401 VDPWR.n145 VDPWR.n144 185
R402 VDPWR.n146 VDPWR.n145 185
R403 VDPWR.n104 VDPWR.n102 185
R404 VDPWR.n132 VDPWR.n130 185
R405 VDPWR.n134 VDPWR.n133 185
R406 VDPWR.n136 VDPWR.n135 185
R407 VDPWR.n137 VDPWR.n105 185
R408 VDPWR.n137 VDPWR.n128 185
R409 VDPWR.n140 VDPWR.n139 185
R410 VDPWR.n141 VDPWR.n107 185
R411 VDPWR.n144 VDPWR.n143 185
R412 VDPWR.n143 VDPWR.n142 185
R413 VDPWR.n112 VDPWR.n106 185
R414 VDPWR.n127 VDPWR.n106 185
R415 VDPWR.n126 VDPWR.n125 185
R416 VDPWR.n109 VDPWR.n108 185
R417 VDPWR.n115 VDPWR.n114 185
R418 VDPWR.n117 VDPWR.n116 185
R419 VDPWR.n119 VDPWR.n118 185
R420 VDPWR.n120 VDPWR.n113 185
R421 VDPWR.n123 VDPWR.n122 185
R422 VDPWR.n122 VDPWR.n121 185
R423 VDPWR.n156 VDPWR.n154 185
R424 VDPWR.n156 VDPWR.n148 185
R425 VDPWR.n198 VDPWR.n149 185
R426 VDPWR.n197 VDPWR.n196 185
R427 VDPWR.n195 VDPWR.n194 185
R428 VDPWR.n195 VDPWR.n150 185
R429 VDPWR.n153 VDPWR.n152 185
R430 VDPWR.n185 VDPWR.n152 185
R431 VDPWR.n188 VDPWR.n187 185
R432 VDPWR.n187 VDPWR.n186 185
R433 VDPWR.n163 VDPWR.n159 185
R434 VDPWR.n184 VDPWR.n159 185
R435 VDPWR.n182 VDPWR.n181 185
R436 VDPWR.n183 VDPWR.n182 185
R437 VDPWR.n162 VDPWR.n161 185
R438 VDPWR.n161 VDPWR.n160 185
R439 VDPWR.n175 VDPWR.n174 185
R440 VDPWR.n174 VDPWR.n173 185
R441 VDPWR.n168 VDPWR.n167 185
R442 VDPWR.n172 VDPWR.n168 185
R443 VDPWR.n171 VDPWR.n170 185
R444 VDPWR.n166 VDPWR.n165 185
R445 VDPWR.n176 VDPWR.n175 185
R446 VDPWR.n177 VDPWR.n176 185
R447 VDPWR.n164 VDPWR.n162 185
R448 VDPWR.n178 VDPWR.n164 185
R449 VDPWR.n181 VDPWR.n180 185
R450 VDPWR.n180 VDPWR.n179 185
R451 VDPWR.n163 VDPWR.n158 185
R452 VDPWR.n158 VDPWR.n157 185
R453 VDPWR.n189 VDPWR.n188 185
R454 VDPWR.n190 VDPWR.n189 185
R455 VDPWR.n155 VDPWR.n153 185
R456 VDPWR.n191 VDPWR.n155 185
R457 VDPWR.n194 VDPWR.n193 185
R458 VDPWR.n193 VDPWR.n192 185
R459 VDPWR.n208 VDPWR.n206 185
R460 VDPWR.n208 VDPWR.n200 185
R461 VDPWR.n250 VDPWR.n201 185
R462 VDPWR.n249 VDPWR.n248 185
R463 VDPWR.n247 VDPWR.n246 185
R464 VDPWR.n247 VDPWR.n202 185
R465 VDPWR.n205 VDPWR.n204 185
R466 VDPWR.n237 VDPWR.n204 185
R467 VDPWR.n240 VDPWR.n239 185
R468 VDPWR.n239 VDPWR.n238 185
R469 VDPWR.n215 VDPWR.n211 185
R470 VDPWR.n236 VDPWR.n211 185
R471 VDPWR.n234 VDPWR.n233 185
R472 VDPWR.n235 VDPWR.n234 185
R473 VDPWR.n214 VDPWR.n213 185
R474 VDPWR.n213 VDPWR.n212 185
R475 VDPWR.n227 VDPWR.n226 185
R476 VDPWR.n226 VDPWR.n225 185
R477 VDPWR.n220 VDPWR.n219 185
R478 VDPWR.n224 VDPWR.n220 185
R479 VDPWR.n223 VDPWR.n222 185
R480 VDPWR.n218 VDPWR.n217 185
R481 VDPWR.n228 VDPWR.n227 185
R482 VDPWR.n229 VDPWR.n228 185
R483 VDPWR.n216 VDPWR.n214 185
R484 VDPWR.n230 VDPWR.n216 185
R485 VDPWR.n233 VDPWR.n232 185
R486 VDPWR.n232 VDPWR.n231 185
R487 VDPWR.n215 VDPWR.n210 185
R488 VDPWR.n210 VDPWR.n209 185
R489 VDPWR.n241 VDPWR.n240 185
R490 VDPWR.n242 VDPWR.n241 185
R491 VDPWR.n207 VDPWR.n205 185
R492 VDPWR.n243 VDPWR.n207 185
R493 VDPWR.n246 VDPWR.n245 185
R494 VDPWR.n245 VDPWR.n244 185
R495 VDPWR.n260 VDPWR.n258 185
R496 VDPWR.n260 VDPWR.n252 185
R497 VDPWR.n302 VDPWR.n253 185
R498 VDPWR.n301 VDPWR.n300 185
R499 VDPWR.n299 VDPWR.n298 185
R500 VDPWR.n299 VDPWR.n254 185
R501 VDPWR.n257 VDPWR.n256 185
R502 VDPWR.n289 VDPWR.n256 185
R503 VDPWR.n292 VDPWR.n291 185
R504 VDPWR.n291 VDPWR.n290 185
R505 VDPWR.n267 VDPWR.n263 185
R506 VDPWR.n288 VDPWR.n263 185
R507 VDPWR.n286 VDPWR.n285 185
R508 VDPWR.n287 VDPWR.n286 185
R509 VDPWR.n266 VDPWR.n265 185
R510 VDPWR.n265 VDPWR.n264 185
R511 VDPWR.n279 VDPWR.n278 185
R512 VDPWR.n278 VDPWR.n277 185
R513 VDPWR.n272 VDPWR.n271 185
R514 VDPWR.n276 VDPWR.n272 185
R515 VDPWR.n275 VDPWR.n274 185
R516 VDPWR.n270 VDPWR.n269 185
R517 VDPWR.n280 VDPWR.n279 185
R518 VDPWR.n281 VDPWR.n280 185
R519 VDPWR.n268 VDPWR.n266 185
R520 VDPWR.n282 VDPWR.n268 185
R521 VDPWR.n285 VDPWR.n284 185
R522 VDPWR.n284 VDPWR.n283 185
R523 VDPWR.n267 VDPWR.n262 185
R524 VDPWR.n262 VDPWR.n261 185
R525 VDPWR.n293 VDPWR.n292 185
R526 VDPWR.n294 VDPWR.n293 185
R527 VDPWR.n259 VDPWR.n257 185
R528 VDPWR.n295 VDPWR.n259 185
R529 VDPWR.n298 VDPWR.n297 185
R530 VDPWR.n297 VDPWR.n296 185
R531 VDPWR.n349 VDPWR.n348 185
R532 VDPWR.n350 VDPWR.n349 185
R533 VDPWR.n313 VDPWR.n312 185
R534 VDPWR.n351 VDPWR.n313 185
R535 VDPWR.n355 VDPWR.n353 185
R536 VDPWR.n353 VDPWR.n352 185
R537 VDPWR.n354 VDPWR.n305 185
R538 VDPWR.n305 VDPWR.n303 185
R539 VDPWR.n406 VDPWR.n405 185
R540 VDPWR.n407 VDPWR.n406 185
R541 VDPWR.n307 VDPWR.n306 185
R542 VDPWR.n306 VDPWR.n304 185
R543 VDPWR.n399 VDPWR.n361 185
R544 VDPWR.n370 VDPWR.n361 185
R545 VDPWR.n398 VDPWR.n362 185
R546 VDPWR.n371 VDPWR.n362 185
R547 VDPWR.n373 VDPWR.n372 185
R548 VDPWR.n375 VDPWR.n374 185
R549 VDPWR.n377 VDPWR.n376 185
R550 VDPWR.n379 VDPWR.n378 185
R551 VDPWR.n381 VDPWR.n380 185
R552 VDPWR.n383 VDPWR.n382 185
R553 VDPWR.n397 VDPWR.n368 185
R554 VDPWR.n384 VDPWR.n368 185
R555 VDPWR.n386 VDPWR.n385 185
R556 VDPWR.n388 VDPWR.n387 185
R557 VDPWR.n390 VDPWR.n389 185
R558 VDPWR.n392 VDPWR.n391 185
R559 VDPWR.n393 VDPWR.n369 185
R560 VDPWR.n395 VDPWR.n394 185
R561 VDPWR.n398 VDPWR.n360 185
R562 VDPWR.n360 VDPWR.n359 185
R563 VDPWR.n400 VDPWR.n399 185
R564 VDPWR.n401 VDPWR.n400 185
R565 VDPWR.n309 VDPWR.n307 185
R566 VDPWR.n402 VDPWR.n309 185
R567 VDPWR.n405 VDPWR.n404 185
R568 VDPWR.n404 VDPWR.n403 185
R569 VDPWR.n354 VDPWR.n308 185
R570 VDPWR.n358 VDPWR.n308 185
R571 VDPWR.n356 VDPWR.n355 185
R572 VDPWR.n357 VDPWR.n356 185
R573 VDPWR.n312 VDPWR.n311 185
R574 VDPWR.n311 VDPWR.n310 185
R575 VDPWR.n348 VDPWR.n347 185
R576 VDPWR.n347 VDPWR.n346 185
R577 VDPWR.n317 VDPWR.n316 185
R578 VDPWR.n345 VDPWR.n317 185
R579 VDPWR.n344 VDPWR.n343 185
R580 VDPWR.n341 VDPWR.n318 185
R581 VDPWR.n340 VDPWR.n316 185
R582 VDPWR.n340 VDPWR.n339 185
R583 VDPWR.n338 VDPWR.n319 185
R584 VDPWR.n337 VDPWR.n336 185
R585 VDPWR.n335 VDPWR.n320 185
R586 VDPWR.n333 VDPWR.n332 185
R587 VDPWR.n331 VDPWR.n322 185
R588 VDPWR.n330 VDPWR.n329 185
R589 VDPWR.n328 VDPWR.n316 185
R590 VDPWR.n328 VDPWR.n323 185
R591 VDPWR.n327 VDPWR.n325 185
R592 VDPWR.n315 VDPWR.n314 185
R593 VDPWR.n455 VDPWR.n454 185
R594 VDPWR.n456 VDPWR.n455 185
R595 VDPWR.n419 VDPWR.n418 185
R596 VDPWR.n457 VDPWR.n419 185
R597 VDPWR.n461 VDPWR.n459 185
R598 VDPWR.n459 VDPWR.n458 185
R599 VDPWR.n460 VDPWR.n411 185
R600 VDPWR.n411 VDPWR.n409 185
R601 VDPWR.n512 VDPWR.n511 185
R602 VDPWR.n513 VDPWR.n512 185
R603 VDPWR.n413 VDPWR.n412 185
R604 VDPWR.n412 VDPWR.n410 185
R605 VDPWR.n505 VDPWR.n467 185
R606 VDPWR.n476 VDPWR.n467 185
R607 VDPWR.n504 VDPWR.n468 185
R608 VDPWR.n477 VDPWR.n468 185
R609 VDPWR.n479 VDPWR.n478 185
R610 VDPWR.n481 VDPWR.n480 185
R611 VDPWR.n503 VDPWR.n473 185
R612 VDPWR.n482 VDPWR.n473 185
R613 VDPWR.n484 VDPWR.n483 185
R614 VDPWR.n486 VDPWR.n485 185
R615 VDPWR.n488 VDPWR.n487 185
R616 VDPWR.n490 VDPWR.n489 185
R617 VDPWR.n492 VDPWR.n491 185
R618 VDPWR.n494 VDPWR.n493 185
R619 VDPWR.n496 VDPWR.n495 185
R620 VDPWR.n498 VDPWR.n497 185
R621 VDPWR.n499 VDPWR.n475 185
R622 VDPWR.n501 VDPWR.n500 185
R623 VDPWR.n504 VDPWR.n466 185
R624 VDPWR.n466 VDPWR.n465 185
R625 VDPWR.n506 VDPWR.n505 185
R626 VDPWR.n507 VDPWR.n506 185
R627 VDPWR.n415 VDPWR.n413 185
R628 VDPWR.n508 VDPWR.n415 185
R629 VDPWR.n511 VDPWR.n510 185
R630 VDPWR.n510 VDPWR.n509 185
R631 VDPWR.n460 VDPWR.n414 185
R632 VDPWR.n464 VDPWR.n414 185
R633 VDPWR.n462 VDPWR.n461 185
R634 VDPWR.n463 VDPWR.n462 185
R635 VDPWR.n418 VDPWR.n417 185
R636 VDPWR.n417 VDPWR.n416 185
R637 VDPWR.n454 VDPWR.n453 185
R638 VDPWR.n453 VDPWR.n452 185
R639 VDPWR.n451 VDPWR.n423 185
R640 VDPWR.n450 VDPWR.n449 185
R641 VDPWR.n448 VDPWR.n422 185
R642 VDPWR.n448 VDPWR.n424 185
R643 VDPWR.n447 VDPWR.n426 185
R644 VDPWR.n445 VDPWR.n444 185
R645 VDPWR.n443 VDPWR.n427 185
R646 VDPWR.n442 VDPWR.n441 185
R647 VDPWR.n440 VDPWR.n422 185
R648 VDPWR.n440 VDPWR.n428 185
R649 VDPWR.n439 VDPWR.n430 185
R650 VDPWR.n437 VDPWR.n436 185
R651 VDPWR.n435 VDPWR.n431 185
R652 VDPWR.n434 VDPWR.n433 185
R653 VDPWR.n422 VDPWR.n421 185
R654 VDPWR.n421 VDPWR.n420 185
R655 VDPWR.n525 VDPWR.n518 185
R656 VDPWR.n596 VDPWR.n525 185
R657 VDPWR.n524 VDPWR.n515 185
R658 VDPWR.n605 VDPWR.n516 185
R659 VDPWR.n604 VDPWR.n603 185
R660 VDPWR.n601 VDPWR.n517 185
R661 VDPWR.n600 VDPWR.n599 185
R662 VDPWR.n600 VDPWR.n520 185
R663 VDPWR.n521 VDPWR.n519 185
R664 VDPWR.n589 VDPWR.n519 185
R665 VDPWR.n592 VDPWR.n591 185
R666 VDPWR.n591 VDPWR.n590 185
R667 VDPWR.n529 VDPWR.n528 185
R668 VDPWR.n588 VDPWR.n529 185
R669 VDPWR.n586 VDPWR.n585 185
R670 VDPWR.n587 VDPWR.n586 185
R671 VDPWR.n532 VDPWR.n531 185
R672 VDPWR.n531 VDPWR.n530 185
R673 VDPWR.n579 VDPWR.n578 185
R674 VDPWR.n578 VDPWR.n577 185
R675 VDPWR.n537 VDPWR.n536 185
R676 VDPWR.n576 VDPWR.n537 185
R677 VDPWR.n574 VDPWR.n573 185
R678 VDPWR.n575 VDPWR.n574 185
R679 VDPWR.n540 VDPWR.n539 185
R680 VDPWR.n539 VDPWR.n538 185
R681 VDPWR.n567 VDPWR.n566 185
R682 VDPWR.n566 VDPWR.n565 185
R683 VDPWR.n545 VDPWR.n544 185
R684 VDPWR.n564 VDPWR.n545 185
R685 VDPWR.n562 VDPWR.n561 185
R686 VDPWR.n563 VDPWR.n562 185
R687 VDPWR.n547 VDPWR.n546 185
R688 VDPWR.n553 VDPWR.n552 185
R689 VDPWR.n554 VDPWR.n548 185
R690 VDPWR.n554 VDPWR.n550 185
R691 VDPWR.n557 VDPWR.n556 185
R692 VDPWR.n558 VDPWR.n549 185
R693 VDPWR.n561 VDPWR.n560 185
R694 VDPWR.n560 VDPWR.n559 185
R695 VDPWR.n544 VDPWR.n543 185
R696 VDPWR.n543 VDPWR.n542 185
R697 VDPWR.n568 VDPWR.n567 185
R698 VDPWR.n569 VDPWR.n568 185
R699 VDPWR.n541 VDPWR.n540 185
R700 VDPWR.n570 VDPWR.n541 185
R701 VDPWR.n573 VDPWR.n572 185
R702 VDPWR.n572 VDPWR.n571 185
R703 VDPWR.n536 VDPWR.n535 185
R704 VDPWR.n535 VDPWR.n534 185
R705 VDPWR.n580 VDPWR.n579 185
R706 VDPWR.n581 VDPWR.n580 185
R707 VDPWR.n533 VDPWR.n532 185
R708 VDPWR.n582 VDPWR.n533 185
R709 VDPWR.n585 VDPWR.n584 185
R710 VDPWR.n584 VDPWR.n583 185
R711 VDPWR.n528 VDPWR.n527 185
R712 VDPWR.n527 VDPWR.n526 185
R713 VDPWR.n593 VDPWR.n592 185
R714 VDPWR.n594 VDPWR.n593 185
R715 VDPWR.n522 VDPWR.n521 185
R716 VDPWR.n595 VDPWR.n522 185
R717 VDPWR.n599 VDPWR.n598 185
R718 VDPWR.n598 VDPWR.n597 185
R719 VDPWR.n616 VDPWR.n609 185
R720 VDPWR.n687 VDPWR.n616 185
R721 VDPWR.n615 VDPWR.n606 185
R722 VDPWR.n696 VDPWR.n607 185
R723 VDPWR.n695 VDPWR.n694 185
R724 VDPWR.n692 VDPWR.n608 185
R725 VDPWR.n691 VDPWR.n690 185
R726 VDPWR.n691 VDPWR.n611 185
R727 VDPWR.n612 VDPWR.n610 185
R728 VDPWR.n680 VDPWR.n610 185
R729 VDPWR.n683 VDPWR.n682 185
R730 VDPWR.n682 VDPWR.n681 185
R731 VDPWR.n620 VDPWR.n619 185
R732 VDPWR.n679 VDPWR.n620 185
R733 VDPWR.n677 VDPWR.n676 185
R734 VDPWR.n678 VDPWR.n677 185
R735 VDPWR.n623 VDPWR.n622 185
R736 VDPWR.n622 VDPWR.n621 185
R737 VDPWR.n670 VDPWR.n669 185
R738 VDPWR.n669 VDPWR.n668 185
R739 VDPWR.n628 VDPWR.n627 185
R740 VDPWR.n667 VDPWR.n628 185
R741 VDPWR.n665 VDPWR.n664 185
R742 VDPWR.n666 VDPWR.n665 185
R743 VDPWR.n631 VDPWR.n630 185
R744 VDPWR.n630 VDPWR.n629 185
R745 VDPWR.n658 VDPWR.n657 185
R746 VDPWR.n657 VDPWR.n656 185
R747 VDPWR.n636 VDPWR.n635 185
R748 VDPWR.n655 VDPWR.n636 185
R749 VDPWR.n653 VDPWR.n652 185
R750 VDPWR.n654 VDPWR.n653 185
R751 VDPWR.n638 VDPWR.n637 185
R752 VDPWR.n644 VDPWR.n643 185
R753 VDPWR.n645 VDPWR.n639 185
R754 VDPWR.n645 VDPWR.n641 185
R755 VDPWR.n648 VDPWR.n647 185
R756 VDPWR.n649 VDPWR.n640 185
R757 VDPWR.n652 VDPWR.n651 185
R758 VDPWR.n651 VDPWR.n650 185
R759 VDPWR.n635 VDPWR.n634 185
R760 VDPWR.n634 VDPWR.n633 185
R761 VDPWR.n659 VDPWR.n658 185
R762 VDPWR.n660 VDPWR.n659 185
R763 VDPWR.n632 VDPWR.n631 185
R764 VDPWR.n661 VDPWR.n632 185
R765 VDPWR.n664 VDPWR.n663 185
R766 VDPWR.n663 VDPWR.n662 185
R767 VDPWR.n627 VDPWR.n626 185
R768 VDPWR.n626 VDPWR.n625 185
R769 VDPWR.n671 VDPWR.n670 185
R770 VDPWR.n672 VDPWR.n671 185
R771 VDPWR.n624 VDPWR.n623 185
R772 VDPWR.n673 VDPWR.n624 185
R773 VDPWR.n676 VDPWR.n675 185
R774 VDPWR.n675 VDPWR.n674 185
R775 VDPWR.n619 VDPWR.n618 185
R776 VDPWR.n618 VDPWR.n617 185
R777 VDPWR.n684 VDPWR.n683 185
R778 VDPWR.n685 VDPWR.n684 185
R779 VDPWR.n613 VDPWR.n612 185
R780 VDPWR.n686 VDPWR.n613 185
R781 VDPWR.n690 VDPWR.n689 185
R782 VDPWR.n689 VDPWR.n688 185
R783 VDPWR.n888 VDPWR.n887 185
R784 VDPWR.n889 VDPWR.n888 185
R785 VDPWR.n708 VDPWR.n707 185
R786 VDPWR.n890 VDPWR.n708 185
R787 VDPWR.n894 VDPWR.n892 185
R788 VDPWR.n892 VDPWR.n891 185
R789 VDPWR.n893 VDPWR.n700 185
R790 VDPWR.n700 VDPWR.n698 185
R791 VDPWR.n1090 VDPWR.n1089 185
R792 VDPWR.n1091 VDPWR.n1090 185
R793 VDPWR.n702 VDPWR.n701 185
R794 VDPWR.n701 VDPWR.n699 185
R795 VDPWR.n1083 VDPWR.n900 185
R796 VDPWR.n941 VDPWR.n900 185
R797 VDPWR.n1082 VDPWR.n901 185
R798 VDPWR.n942 VDPWR.n901 185
R799 VDPWR.n944 VDPWR.n943 185
R800 VDPWR.n946 VDPWR.n945 185
R801 VDPWR.n948 VDPWR.n947 185
R802 VDPWR.n950 VDPWR.n949 185
R803 VDPWR.n952 VDPWR.n951 185
R804 VDPWR.n954 VDPWR.n953 185
R805 VDPWR.n956 VDPWR.n955 185
R806 VDPWR.n958 VDPWR.n957 185
R807 VDPWR.n1081 VDPWR.n918 185
R808 VDPWR.n959 VDPWR.n918 185
R809 VDPWR.n961 VDPWR.n960 185
R810 VDPWR.n963 VDPWR.n962 185
R811 VDPWR.n965 VDPWR.n964 185
R812 VDPWR.n967 VDPWR.n966 185
R813 VDPWR.n1081 VDPWR.n924 185
R814 VDPWR.n968 VDPWR.n924 185
R815 VDPWR.n970 VDPWR.n969 185
R816 VDPWR.n972 VDPWR.n971 185
R817 VDPWR.n974 VDPWR.n973 185
R818 VDPWR.n976 VDPWR.n975 185
R819 VDPWR.n978 VDPWR.n977 185
R820 VDPWR.n980 VDPWR.n979 185
R821 VDPWR.n982 VDPWR.n981 185
R822 VDPWR.n984 VDPWR.n983 185
R823 VDPWR.n986 VDPWR.n985 185
R824 VDPWR.n988 VDPWR.n987 185
R825 VDPWR.n990 VDPWR.n989 185
R826 VDPWR.n992 VDPWR.n991 185
R827 VDPWR.n1081 VDPWR.n912 185
R828 VDPWR.n993 VDPWR.n912 185
R829 VDPWR.n995 VDPWR.n994 185
R830 VDPWR.n997 VDPWR.n996 185
R831 VDPWR.n999 VDPWR.n998 185
R832 VDPWR.n1001 VDPWR.n1000 185
R833 VDPWR.n1003 VDPWR.n1002 185
R834 VDPWR.n1005 VDPWR.n1004 185
R835 VDPWR.n1007 VDPWR.n1006 185
R836 VDPWR.n1009 VDPWR.n1008 185
R837 VDPWR.n1011 VDPWR.n1010 185
R838 VDPWR.n1013 VDPWR.n1012 185
R839 VDPWR.n1081 VDPWR.n932 185
R840 VDPWR.n1014 VDPWR.n932 185
R841 VDPWR.n1016 VDPWR.n1015 185
R842 VDPWR.n1018 VDPWR.n1017 185
R843 VDPWR.n1020 VDPWR.n1019 185
R844 VDPWR.n1022 VDPWR.n1021 185
R845 VDPWR.n1024 VDPWR.n1023 185
R846 VDPWR.n1026 VDPWR.n1025 185
R847 VDPWR.n1028 VDPWR.n1027 185
R848 VDPWR.n1030 VDPWR.n1029 185
R849 VDPWR.n1032 VDPWR.n1031 185
R850 VDPWR.n1034 VDPWR.n1033 185
R851 VDPWR.n1036 VDPWR.n1035 185
R852 VDPWR.n1038 VDPWR.n1037 185
R853 VDPWR.n1040 VDPWR.n1039 185
R854 VDPWR.n1042 VDPWR.n1041 185
R855 VDPWR.n1044 VDPWR.n1043 185
R856 VDPWR.n1046 VDPWR.n1045 185
R857 VDPWR.n1081 VDPWR.n905 185
R858 VDPWR.n1047 VDPWR.n905 185
R859 VDPWR.n1049 VDPWR.n1048 185
R860 VDPWR.n1051 VDPWR.n1050 185
R861 VDPWR.n1053 VDPWR.n1052 185
R862 VDPWR.n1055 VDPWR.n1054 185
R863 VDPWR.n1057 VDPWR.n1056 185
R864 VDPWR.n1059 VDPWR.n1058 185
R865 VDPWR.n1061 VDPWR.n1060 185
R866 VDPWR.n1063 VDPWR.n1062 185
R867 VDPWR.n1081 VDPWR.n938 185
R868 VDPWR.n1064 VDPWR.n938 185
R869 VDPWR.n1066 VDPWR.n1065 185
R870 VDPWR.n1068 VDPWR.n1067 185
R871 VDPWR.n1070 VDPWR.n1069 185
R872 VDPWR.n1072 VDPWR.n1071 185
R873 VDPWR.n1074 VDPWR.n1073 185
R874 VDPWR.n1076 VDPWR.n1075 185
R875 VDPWR.n1077 VDPWR.n940 185
R876 VDPWR.n1079 VDPWR.n1078 185
R877 VDPWR.n1082 VDPWR.n899 185
R878 VDPWR.n899 VDPWR.n898 185
R879 VDPWR.n1084 VDPWR.n1083 185
R880 VDPWR.n1085 VDPWR.n1084 185
R881 VDPWR.n704 VDPWR.n702 185
R882 VDPWR.n1086 VDPWR.n704 185
R883 VDPWR.n1089 VDPWR.n1088 185
R884 VDPWR.n1088 VDPWR.n1087 185
R885 VDPWR.n893 VDPWR.n703 185
R886 VDPWR.n897 VDPWR.n703 185
R887 VDPWR.n895 VDPWR.n894 185
R888 VDPWR.n896 VDPWR.n895 185
R889 VDPWR.n707 VDPWR.n706 185
R890 VDPWR.n706 VDPWR.n705 185
R891 VDPWR.n887 VDPWR.n886 185
R892 VDPWR.n886 VDPWR.n885 185
R893 VDPWR.n884 VDPWR.n712 185
R894 VDPWR.n883 VDPWR.n882 185
R895 VDPWR.n881 VDPWR.n713 185
R896 VDPWR.n879 VDPWR.n878 185
R897 VDPWR.n715 VDPWR.n711 185
R898 VDPWR.n877 VDPWR.n715 185
R899 VDPWR.n876 VDPWR.n875 185
R900 VDPWR.n873 VDPWR.n716 185
R901 VDPWR.n872 VDPWR.n717 185
R902 VDPWR.n870 VDPWR.n869 185
R903 VDPWR.n718 VDPWR.n711 185
R904 VDPWR.n868 VDPWR.n718 185
R905 VDPWR.n867 VDPWR.n866 185
R906 VDPWR.n864 VDPWR.n719 185
R907 VDPWR.n863 VDPWR.n720 185
R908 VDPWR.n861 VDPWR.n860 185
R909 VDPWR.n859 VDPWR.n721 185
R910 VDPWR.n858 VDPWR.n857 185
R911 VDPWR.n856 VDPWR.n722 185
R912 VDPWR.n854 VDPWR.n853 185
R913 VDPWR.n724 VDPWR.n711 185
R914 VDPWR.n852 VDPWR.n724 185
R915 VDPWR.n851 VDPWR.n850 185
R916 VDPWR.n848 VDPWR.n725 185
R917 VDPWR.n847 VDPWR.n711 185
R918 VDPWR.n847 VDPWR.n846 185
R919 VDPWR.n845 VDPWR.n726 185
R920 VDPWR.n844 VDPWR.n843 185
R921 VDPWR.n842 VDPWR.n727 185
R922 VDPWR.n840 VDPWR.n839 185
R923 VDPWR.n838 VDPWR.n729 185
R924 VDPWR.n837 VDPWR.n836 185
R925 VDPWR.n835 VDPWR.n711 185
R926 VDPWR.n835 VDPWR.n730 185
R927 VDPWR.n834 VDPWR.n732 185
R928 VDPWR.n832 VDPWR.n831 185
R929 VDPWR.n733 VDPWR.n711 185
R930 VDPWR.n830 VDPWR.n733 185
R931 VDPWR.n829 VDPWR.n828 185
R932 VDPWR.n826 VDPWR.n734 185
R933 VDPWR.n825 VDPWR.n735 185
R934 VDPWR.n823 VDPWR.n822 185
R935 VDPWR.n821 VDPWR.n736 185
R936 VDPWR.n820 VDPWR.n819 185
R937 VDPWR.n818 VDPWR.n737 185
R938 VDPWR.n816 VDPWR.n815 185
R939 VDPWR.n814 VDPWR.n739 185
R940 VDPWR.n813 VDPWR.n812 185
R941 VDPWR.n811 VDPWR.n711 185
R942 VDPWR.n811 VDPWR.n740 185
R943 VDPWR.n810 VDPWR.n742 185
R944 VDPWR.n808 VDPWR.n807 185
R945 VDPWR.n806 VDPWR.n743 185
R946 VDPWR.n805 VDPWR.n804 185
R947 VDPWR.n803 VDPWR.n744 185
R948 VDPWR.n801 VDPWR.n800 185
R949 VDPWR.n799 VDPWR.n746 185
R950 VDPWR.n798 VDPWR.n797 185
R951 VDPWR.n796 VDPWR.n747 185
R952 VDPWR.n794 VDPWR.n793 185
R953 VDPWR.n792 VDPWR.n749 185
R954 VDPWR.n791 VDPWR.n790 185
R955 VDPWR.n789 VDPWR.n750 185
R956 VDPWR.n787 VDPWR.n786 185
R957 VDPWR.n785 VDPWR.n752 185
R958 VDPWR.n784 VDPWR.n783 185
R959 VDPWR.n782 VDPWR.n711 185
R960 VDPWR.n782 VDPWR.n753 185
R961 VDPWR.n781 VDPWR.n755 185
R962 VDPWR.n779 VDPWR.n778 185
R963 VDPWR.n756 VDPWR.n711 185
R964 VDPWR.n777 VDPWR.n756 185
R965 VDPWR.n776 VDPWR.n775 185
R966 VDPWR.n773 VDPWR.n757 185
R967 VDPWR.n772 VDPWR.n758 185
R968 VDPWR.n770 VDPWR.n769 185
R969 VDPWR.n768 VDPWR.n759 185
R970 VDPWR.n767 VDPWR.n766 185
R971 VDPWR.n765 VDPWR.n711 185
R972 VDPWR.n765 VDPWR.n760 185
R973 VDPWR.n764 VDPWR.n762 185
R974 VDPWR.n710 VDPWR.n709 185
R975 VDPWR.n49 VDPWR.n10 153.386
R976 VDPWR.n28 VDPWR.n17 153.386
R977 VDPWR.n97 VDPWR.n58 153.386
R978 VDPWR.n76 VDPWR.n65 153.386
R979 VDPWR.n144 VDPWR.n105 153.386
R980 VDPWR.n123 VDPWR.n112 153.386
R981 VDPWR.n194 VDPWR.n153 139.827
R982 VDPWR.n188 VDPWR.n153 139.827
R983 VDPWR.n181 VDPWR.n163 139.827
R984 VDPWR.n181 VDPWR.n162 139.827
R985 VDPWR.n175 VDPWR.n162 139.827
R986 VDPWR.n246 VDPWR.n205 139.827
R987 VDPWR.n240 VDPWR.n205 139.827
R988 VDPWR.n233 VDPWR.n215 139.827
R989 VDPWR.n233 VDPWR.n214 139.827
R990 VDPWR.n227 VDPWR.n214 139.827
R991 VDPWR.n298 VDPWR.n257 139.827
R992 VDPWR.n292 VDPWR.n257 139.827
R993 VDPWR.n285 VDPWR.n267 139.827
R994 VDPWR.n285 VDPWR.n266 139.827
R995 VDPWR.n279 VDPWR.n266 139.827
R996 VDPWR.n599 VDPWR.n521 109.123
R997 VDPWR.n592 VDPWR.n521 109.123
R998 VDPWR.n592 VDPWR.n528 109.123
R999 VDPWR.n585 VDPWR.n528 109.123
R1000 VDPWR.n585 VDPWR.n532 109.123
R1001 VDPWR.n579 VDPWR.n536 109.123
R1002 VDPWR.n573 VDPWR.n536 109.123
R1003 VDPWR.n573 VDPWR.n540 109.123
R1004 VDPWR.n567 VDPWR.n540 109.123
R1005 VDPWR.n567 VDPWR.n544 109.123
R1006 VDPWR.n561 VDPWR.n544 109.123
R1007 VDPWR.n690 VDPWR.n612 109.123
R1008 VDPWR.n683 VDPWR.n612 109.123
R1009 VDPWR.n683 VDPWR.n619 109.123
R1010 VDPWR.n676 VDPWR.n619 109.123
R1011 VDPWR.n676 VDPWR.n623 109.123
R1012 VDPWR.n670 VDPWR.n627 109.123
R1013 VDPWR.n664 VDPWR.n627 109.123
R1014 VDPWR.n664 VDPWR.n631 109.123
R1015 VDPWR.n658 VDPWR.n631 109.123
R1016 VDPWR.n658 VDPWR.n635 109.123
R1017 VDPWR.n652 VDPWR.n635 109.123
R1018 VDPWR.n51 VDPWR.n7 88.0946
R1019 VDPWR.n47 VDPWR.n46 88.0946
R1020 VDPWR.n26 VDPWR.n6 88.0946
R1021 VDPWR.n32 VDPWR.n31 88.0946
R1022 VDPWR.n99 VDPWR.n55 88.0946
R1023 VDPWR.n95 VDPWR.n94 88.0946
R1024 VDPWR.n74 VDPWR.n54 88.0946
R1025 VDPWR.n80 VDPWR.n79 88.0946
R1026 VDPWR.n146 VDPWR.n102 88.0946
R1027 VDPWR.n142 VDPWR.n141 88.0946
R1028 VDPWR.n121 VDPWR.n101 88.0946
R1029 VDPWR.n127 VDPWR.n126 88.0946
R1030 VDPWR.n398 VDPWR.n397 85.4029
R1031 VDPWR.n348 VDPWR.n316 85.4029
R1032 VDPWR.n504 VDPWR.n503 85.4029
R1033 VDPWR.n454 VDPWR.n422 85.4029
R1034 VDPWR.n197 VDPWR.n150 82.824
R1035 VDPWR.n173 VDPWR.n172 82.824
R1036 VDPWR.n192 VDPWR.n148 82.824
R1037 VDPWR.n177 VDPWR.n165 82.824
R1038 VDPWR.n249 VDPWR.n202 82.824
R1039 VDPWR.n225 VDPWR.n224 82.824
R1040 VDPWR.n244 VDPWR.n200 82.824
R1041 VDPWR.n229 VDPWR.n217 82.824
R1042 VDPWR.n301 VDPWR.n254 82.824
R1043 VDPWR.n277 VDPWR.n276 82.824
R1044 VDPWR.n296 VDPWR.n252 82.824
R1045 VDPWR.n281 VDPWR.n269 82.824
R1046 VDPWR.n520 VDPWR.n517 80.1887
R1047 VDPWR.n563 VDPWR.n546 80.1887
R1048 VDPWR.n597 VDPWR.n596 80.1887
R1049 VDPWR.n559 VDPWR.n558 80.1887
R1050 VDPWR.n611 VDPWR.n608 80.1887
R1051 VDPWR.n654 VDPWR.n637 80.1887
R1052 VDPWR.n688 VDPWR.n687 80.1887
R1053 VDPWR.n650 VDPWR.n649 80.1887
R1054 VDPWR.n373 VDPWR.n371 79.4358
R1055 VDPWR.n394 VDPWR.n359 79.4358
R1056 VDPWR.n350 VDPWR.n314 79.4358
R1057 VDPWR.n346 VDPWR.n345 79.4358
R1058 VDPWR.n479 VDPWR.n477 79.4358
R1059 VDPWR.n500 VDPWR.n465 79.4358
R1060 VDPWR.n456 VDPWR.n420 79.4358
R1061 VDPWR.n452 VDPWR.n451 79.4358
R1062 VDPWR.n944 VDPWR.n942 77.177
R1063 VDPWR.n1078 VDPWR.n898 77.177
R1064 VDPWR.n889 VDPWR.n709 77.177
R1065 VDPWR.n885 VDPWR.n884 77.177
R1066 VDPWR.n163 VDPWR.t1 74.0265
R1067 VDPWR.n215 VDPWR.t0 74.0265
R1068 VDPWR.n267 VDPWR.t2 74.0265
R1069 VDPWR.n36 VDPWR.n9 72.7879
R1070 VDPWR.n38 VDPWR.n34 72.7879
R1071 VDPWR.n44 VDPWR.n43 72.7879
R1072 VDPWR.n29 VDPWR.n14 72.7879
R1073 VDPWR.n22 VDPWR.n15 72.7879
R1074 VDPWR.n18 VDPWR.n16 72.7879
R1075 VDPWR.n23 VDPWR.n16 72.7879
R1076 VDPWR.n19 VDPWR.n15 72.7879
R1077 VDPWR.n30 VDPWR.n29 72.7879
R1078 VDPWR.n37 VDPWR.n36 72.7879
R1079 VDPWR.n41 VDPWR.n34 72.7879
R1080 VDPWR.n43 VDPWR.n12 72.7879
R1081 VDPWR.n84 VDPWR.n57 72.7879
R1082 VDPWR.n86 VDPWR.n82 72.7879
R1083 VDPWR.n92 VDPWR.n91 72.7879
R1084 VDPWR.n77 VDPWR.n62 72.7879
R1085 VDPWR.n70 VDPWR.n63 72.7879
R1086 VDPWR.n66 VDPWR.n64 72.7879
R1087 VDPWR.n71 VDPWR.n64 72.7879
R1088 VDPWR.n67 VDPWR.n63 72.7879
R1089 VDPWR.n78 VDPWR.n77 72.7879
R1090 VDPWR.n85 VDPWR.n84 72.7879
R1091 VDPWR.n89 VDPWR.n82 72.7879
R1092 VDPWR.n91 VDPWR.n60 72.7879
R1093 VDPWR.n131 VDPWR.n104 72.7879
R1094 VDPWR.n133 VDPWR.n129 72.7879
R1095 VDPWR.n139 VDPWR.n138 72.7879
R1096 VDPWR.n124 VDPWR.n109 72.7879
R1097 VDPWR.n117 VDPWR.n110 72.7879
R1098 VDPWR.n113 VDPWR.n111 72.7879
R1099 VDPWR.n118 VDPWR.n111 72.7879
R1100 VDPWR.n114 VDPWR.n110 72.7879
R1101 VDPWR.n125 VDPWR.n124 72.7879
R1102 VDPWR.n132 VDPWR.n131 72.7879
R1103 VDPWR.n136 VDPWR.n129 72.7879
R1104 VDPWR.n138 VDPWR.n107 72.7879
R1105 VDPWR.n151 VDPWR.n149 72.7879
R1106 VDPWR.n170 VDPWR.n169 72.7879
R1107 VDPWR.n196 VDPWR.n151 72.7879
R1108 VDPWR.n169 VDPWR.n166 72.7879
R1109 VDPWR.n203 VDPWR.n201 72.7879
R1110 VDPWR.n222 VDPWR.n221 72.7879
R1111 VDPWR.n248 VDPWR.n203 72.7879
R1112 VDPWR.n221 VDPWR.n218 72.7879
R1113 VDPWR.n255 VDPWR.n253 72.7879
R1114 VDPWR.n274 VDPWR.n273 72.7879
R1115 VDPWR.n300 VDPWR.n255 72.7879
R1116 VDPWR.n273 VDPWR.n270 72.7879
R1117 VDPWR.n375 VDPWR.n366 72.7879
R1118 VDPWR.n376 VDPWR.n365 72.7879
R1119 VDPWR.n382 VDPWR.n367 72.7879
R1120 VDPWR.n388 VDPWR.n364 72.7879
R1121 VDPWR.n391 VDPWR.n363 72.7879
R1122 VDPWR.n396 VDPWR.n369 72.7879
R1123 VDPWR.n343 VDPWR.n342 72.7879
R1124 VDPWR.n321 VDPWR.n319 72.7879
R1125 VDPWR.n334 VDPWR.n333 72.7879
R1126 VDPWR.n324 VDPWR.n322 72.7879
R1127 VDPWR.n327 VDPWR.n326 72.7879
R1128 VDPWR.n326 VDPWR.n315 72.7879
R1129 VDPWR.n329 VDPWR.n324 72.7879
R1130 VDPWR.n335 VDPWR.n334 72.7879
R1131 VDPWR.n336 VDPWR.n321 72.7879
R1132 VDPWR.n342 VDPWR.n341 72.7879
R1133 VDPWR.n372 VDPWR.n366 72.7879
R1134 VDPWR.n379 VDPWR.n365 72.7879
R1135 VDPWR.n380 VDPWR.n367 72.7879
R1136 VDPWR.n385 VDPWR.n364 72.7879
R1137 VDPWR.n389 VDPWR.n363 72.7879
R1138 VDPWR.n396 VDPWR.n395 72.7879
R1139 VDPWR.n478 VDPWR.n472 72.7879
R1140 VDPWR.n486 VDPWR.n471 72.7879
R1141 VDPWR.n490 VDPWR.n470 72.7879
R1142 VDPWR.n494 VDPWR.n469 72.7879
R1143 VDPWR.n495 VDPWR.n474 72.7879
R1144 VDPWR.n502 VDPWR.n475 72.7879
R1145 VDPWR.n425 VDPWR.n423 72.7879
R1146 VDPWR.n447 VDPWR.n446 72.7879
R1147 VDPWR.n429 VDPWR.n427 72.7879
R1148 VDPWR.n439 VDPWR.n438 72.7879
R1149 VDPWR.n432 VDPWR.n431 72.7879
R1150 VDPWR.n433 VDPWR.n432 72.7879
R1151 VDPWR.n438 VDPWR.n437 72.7879
R1152 VDPWR.n441 VDPWR.n429 72.7879
R1153 VDPWR.n446 VDPWR.n445 72.7879
R1154 VDPWR.n449 VDPWR.n425 72.7879
R1155 VDPWR.n480 VDPWR.n472 72.7879
R1156 VDPWR.n483 VDPWR.n471 72.7879
R1157 VDPWR.n487 VDPWR.n470 72.7879
R1158 VDPWR.n491 VDPWR.n469 72.7879
R1159 VDPWR.n497 VDPWR.n474 72.7879
R1160 VDPWR.n502 VDPWR.n501 72.7879
R1161 VDPWR.n524 VDPWR.n523 72.7879
R1162 VDPWR.n603 VDPWR.n602 72.7879
R1163 VDPWR.n551 VDPWR.n547 72.7879
R1164 VDPWR.n556 VDPWR.n555 72.7879
R1165 VDPWR.n602 VDPWR.n601 72.7879
R1166 VDPWR.n523 VDPWR.n516 72.7879
R1167 VDPWR.n553 VDPWR.n551 72.7879
R1168 VDPWR.n555 VDPWR.n549 72.7879
R1169 VDPWR.n615 VDPWR.n614 72.7879
R1170 VDPWR.n694 VDPWR.n693 72.7879
R1171 VDPWR.n642 VDPWR.n638 72.7879
R1172 VDPWR.n647 VDPWR.n646 72.7879
R1173 VDPWR.n693 VDPWR.n692 72.7879
R1174 VDPWR.n614 VDPWR.n607 72.7879
R1175 VDPWR.n644 VDPWR.n642 72.7879
R1176 VDPWR.n646 VDPWR.n640 72.7879
R1177 VDPWR.n946 VDPWR.n921 72.7879
R1178 VDPWR.n947 VDPWR.n922 72.7879
R1179 VDPWR.n954 VDPWR.n920 72.7879
R1180 VDPWR.n957 VDPWR.n919 72.7879
R1181 VDPWR.n960 VDPWR.n917 72.7879
R1182 VDPWR.n966 VDPWR.n923 72.7879
R1183 VDPWR.n972 VDPWR.n916 72.7879
R1184 VDPWR.n973 VDPWR.n925 72.7879
R1185 VDPWR.n980 VDPWR.n915 72.7879
R1186 VDPWR.n984 VDPWR.n914 72.7879
R1187 VDPWR.n985 VDPWR.n926 72.7879
R1188 VDPWR.n991 VDPWR.n913 72.7879
R1189 VDPWR.n997 VDPWR.n927 72.7879
R1190 VDPWR.n1001 VDPWR.n928 72.7879
R1191 VDPWR.n1005 VDPWR.n929 72.7879
R1192 VDPWR.n1009 VDPWR.n930 72.7879
R1193 VDPWR.n1012 VDPWR.n931 72.7879
R1194 VDPWR.n1015 VDPWR.n933 72.7879
R1195 VDPWR.n1022 VDPWR.n911 72.7879
R1196 VDPWR.n1026 VDPWR.n910 72.7879
R1197 VDPWR.n1027 VDPWR.n934 72.7879
R1198 VDPWR.n1034 VDPWR.n909 72.7879
R1199 VDPWR.n1038 VDPWR.n908 72.7879
R1200 VDPWR.n1042 VDPWR.n907 72.7879
R1201 VDPWR.n1045 VDPWR.n906 72.7879
R1202 VDPWR.n1051 VDPWR.n935 72.7879
R1203 VDPWR.n1052 VDPWR.n904 72.7879
R1204 VDPWR.n1059 VDPWR.n936 72.7879
R1205 VDPWR.n1062 VDPWR.n937 72.7879
R1206 VDPWR.n1065 VDPWR.n939 72.7879
R1207 VDPWR.n1072 VDPWR.n903 72.7879
R1208 VDPWR.n1075 VDPWR.n902 72.7879
R1209 VDPWR.n1080 VDPWR.n940 72.7879
R1210 VDPWR.n714 VDPWR.n712 72.7879
R1211 VDPWR.n881 VDPWR.n880 72.7879
R1212 VDPWR.n875 VDPWR.n874 72.7879
R1213 VDPWR.n872 VDPWR.n871 72.7879
R1214 VDPWR.n866 VDPWR.n865 72.7879
R1215 VDPWR.n863 VDPWR.n862 72.7879
R1216 VDPWR.n723 VDPWR.n721 72.7879
R1217 VDPWR.n856 VDPWR.n855 72.7879
R1218 VDPWR.n850 VDPWR.n849 72.7879
R1219 VDPWR.n728 VDPWR.n726 72.7879
R1220 VDPWR.n841 VDPWR.n840 72.7879
R1221 VDPWR.n731 VDPWR.n729 72.7879
R1222 VDPWR.n834 VDPWR.n833 72.7879
R1223 VDPWR.n828 VDPWR.n827 72.7879
R1224 VDPWR.n825 VDPWR.n824 72.7879
R1225 VDPWR.n738 VDPWR.n736 72.7879
R1226 VDPWR.n817 VDPWR.n816 72.7879
R1227 VDPWR.n741 VDPWR.n739 72.7879
R1228 VDPWR.n810 VDPWR.n809 72.7879
R1229 VDPWR.n745 VDPWR.n743 72.7879
R1230 VDPWR.n802 VDPWR.n801 72.7879
R1231 VDPWR.n748 VDPWR.n746 72.7879
R1232 VDPWR.n795 VDPWR.n794 72.7879
R1233 VDPWR.n751 VDPWR.n749 72.7879
R1234 VDPWR.n789 VDPWR.n788 72.7879
R1235 VDPWR.n754 VDPWR.n752 72.7879
R1236 VDPWR.n781 VDPWR.n780 72.7879
R1237 VDPWR.n775 VDPWR.n774 72.7879
R1238 VDPWR.n772 VDPWR.n771 72.7879
R1239 VDPWR.n761 VDPWR.n759 72.7879
R1240 VDPWR.n764 VDPWR.n763 72.7879
R1241 VDPWR.n763 VDPWR.n710 72.7879
R1242 VDPWR.n766 VDPWR.n761 72.7879
R1243 VDPWR.n771 VDPWR.n770 72.7879
R1244 VDPWR.n774 VDPWR.n773 72.7879
R1245 VDPWR.n780 VDPWR.n779 72.7879
R1246 VDPWR.n783 VDPWR.n754 72.7879
R1247 VDPWR.n788 VDPWR.n787 72.7879
R1248 VDPWR.n790 VDPWR.n751 72.7879
R1249 VDPWR.n796 VDPWR.n795 72.7879
R1250 VDPWR.n797 VDPWR.n748 72.7879
R1251 VDPWR.n803 VDPWR.n802 72.7879
R1252 VDPWR.n804 VDPWR.n745 72.7879
R1253 VDPWR.n809 VDPWR.n808 72.7879
R1254 VDPWR.n812 VDPWR.n741 72.7879
R1255 VDPWR.n818 VDPWR.n817 72.7879
R1256 VDPWR.n819 VDPWR.n738 72.7879
R1257 VDPWR.n824 VDPWR.n823 72.7879
R1258 VDPWR.n827 VDPWR.n826 72.7879
R1259 VDPWR.n833 VDPWR.n832 72.7879
R1260 VDPWR.n836 VDPWR.n731 72.7879
R1261 VDPWR.n842 VDPWR.n841 72.7879
R1262 VDPWR.n843 VDPWR.n728 72.7879
R1263 VDPWR.n849 VDPWR.n848 72.7879
R1264 VDPWR.n855 VDPWR.n854 72.7879
R1265 VDPWR.n857 VDPWR.n723 72.7879
R1266 VDPWR.n862 VDPWR.n861 72.7879
R1267 VDPWR.n865 VDPWR.n864 72.7879
R1268 VDPWR.n871 VDPWR.n870 72.7879
R1269 VDPWR.n874 VDPWR.n873 72.7879
R1270 VDPWR.n880 VDPWR.n879 72.7879
R1271 VDPWR.n882 VDPWR.n714 72.7879
R1272 VDPWR.n943 VDPWR.n921 72.7879
R1273 VDPWR.n950 VDPWR.n922 72.7879
R1274 VDPWR.n951 VDPWR.n920 72.7879
R1275 VDPWR.n955 VDPWR.n919 72.7879
R1276 VDPWR.n963 VDPWR.n917 72.7879
R1277 VDPWR.n964 VDPWR.n923 72.7879
R1278 VDPWR.n969 VDPWR.n916 72.7879
R1279 VDPWR.n976 VDPWR.n925 72.7879
R1280 VDPWR.n977 VDPWR.n915 72.7879
R1281 VDPWR.n981 VDPWR.n914 72.7879
R1282 VDPWR.n988 VDPWR.n926 72.7879
R1283 VDPWR.n989 VDPWR.n913 72.7879
R1284 VDPWR.n994 VDPWR.n927 72.7879
R1285 VDPWR.n998 VDPWR.n928 72.7879
R1286 VDPWR.n1002 VDPWR.n929 72.7879
R1287 VDPWR.n1006 VDPWR.n930 72.7879
R1288 VDPWR.n1010 VDPWR.n931 72.7879
R1289 VDPWR.n1018 VDPWR.n933 72.7879
R1290 VDPWR.n1019 VDPWR.n911 72.7879
R1291 VDPWR.n1023 VDPWR.n910 72.7879
R1292 VDPWR.n1030 VDPWR.n934 72.7879
R1293 VDPWR.n1031 VDPWR.n909 72.7879
R1294 VDPWR.n1035 VDPWR.n908 72.7879
R1295 VDPWR.n1039 VDPWR.n907 72.7879
R1296 VDPWR.n1043 VDPWR.n906 72.7879
R1297 VDPWR.n1048 VDPWR.n935 72.7879
R1298 VDPWR.n1055 VDPWR.n904 72.7879
R1299 VDPWR.n1056 VDPWR.n936 72.7879
R1300 VDPWR.n1060 VDPWR.n937 72.7879
R1301 VDPWR.n1068 VDPWR.n939 72.7879
R1302 VDPWR.n1069 VDPWR.n903 72.7879
R1303 VDPWR.n1073 VDPWR.n902 72.7879
R1304 VDPWR.n1080 VDPWR.n1079 72.7879
R1305 VDPWR.n0 VDPWR.t8 72.3676
R1306 VDPWR.n1 VDPWR.t6 72.3676
R1307 VDPWR.n188 VDPWR.t1 65.8014
R1308 VDPWR.n240 VDPWR.t0 65.8014
R1309 VDPWR.n292 VDPWR.t2 65.8014
R1310 VDPWR.n579 VDPWR.t9 57.7708
R1311 VDPWR.n670 VDPWR.t14 57.7708
R1312 VDPWR.n36 VDPWR.n10 56.1076
R1313 VDPWR.n34 VDPWR.n10 56.1076
R1314 VDPWR.n43 VDPWR.n10 56.1076
R1315 VDPWR.n29 VDPWR.n28 56.1076
R1316 VDPWR.n28 VDPWR.n15 56.1076
R1317 VDPWR.n28 VDPWR.n16 56.1076
R1318 VDPWR.n84 VDPWR.n58 56.1076
R1319 VDPWR.n82 VDPWR.n58 56.1076
R1320 VDPWR.n91 VDPWR.n58 56.1076
R1321 VDPWR.n77 VDPWR.n76 56.1076
R1322 VDPWR.n76 VDPWR.n63 56.1076
R1323 VDPWR.n76 VDPWR.n64 56.1076
R1324 VDPWR.n131 VDPWR.n105 56.1076
R1325 VDPWR.n129 VDPWR.n105 56.1076
R1326 VDPWR.n138 VDPWR.n105 56.1076
R1327 VDPWR.n124 VDPWR.n123 56.1076
R1328 VDPWR.n123 VDPWR.n110 56.1076
R1329 VDPWR.n123 VDPWR.n111 56.1076
R1330 VDPWR.n154 VDPWR.n151 56.1076
R1331 VDPWR.n169 VDPWR.n167 56.1076
R1332 VDPWR.n206 VDPWR.n203 56.1076
R1333 VDPWR.n221 VDPWR.n219 56.1076
R1334 VDPWR.n258 VDPWR.n255 56.1076
R1335 VDPWR.n273 VDPWR.n271 56.1076
R1336 VDPWR.n397 VDPWR.n366 56.1076
R1337 VDPWR.n397 VDPWR.n365 56.1076
R1338 VDPWR.n397 VDPWR.n367 56.1076
R1339 VDPWR.n397 VDPWR.n364 56.1076
R1340 VDPWR.n397 VDPWR.n363 56.1076
R1341 VDPWR.n397 VDPWR.n396 56.1076
R1342 VDPWR.n342 VDPWR.n316 56.1076
R1343 VDPWR.n321 VDPWR.n316 56.1076
R1344 VDPWR.n334 VDPWR.n316 56.1076
R1345 VDPWR.n324 VDPWR.n316 56.1076
R1346 VDPWR.n326 VDPWR.n316 56.1076
R1347 VDPWR.n503 VDPWR.n472 56.1076
R1348 VDPWR.n503 VDPWR.n471 56.1076
R1349 VDPWR.n503 VDPWR.n470 56.1076
R1350 VDPWR.n503 VDPWR.n469 56.1076
R1351 VDPWR.n503 VDPWR.n474 56.1076
R1352 VDPWR.n503 VDPWR.n502 56.1076
R1353 VDPWR.n425 VDPWR.n422 56.1076
R1354 VDPWR.n446 VDPWR.n422 56.1076
R1355 VDPWR.n429 VDPWR.n422 56.1076
R1356 VDPWR.n438 VDPWR.n422 56.1076
R1357 VDPWR.n432 VDPWR.n422 56.1076
R1358 VDPWR.n523 VDPWR.n518 56.1076
R1359 VDPWR.n602 VDPWR.n518 56.1076
R1360 VDPWR.n551 VDPWR.n548 56.1076
R1361 VDPWR.n555 VDPWR.n548 56.1076
R1362 VDPWR.n614 VDPWR.n609 56.1076
R1363 VDPWR.n693 VDPWR.n609 56.1076
R1364 VDPWR.n642 VDPWR.n639 56.1076
R1365 VDPWR.n646 VDPWR.n639 56.1076
R1366 VDPWR.n1081 VDPWR.n921 56.1076
R1367 VDPWR.n1081 VDPWR.n922 56.1076
R1368 VDPWR.n1081 VDPWR.n920 56.1076
R1369 VDPWR.n1081 VDPWR.n919 56.1076
R1370 VDPWR.n1081 VDPWR.n917 56.1076
R1371 VDPWR.n1081 VDPWR.n923 56.1076
R1372 VDPWR.n1081 VDPWR.n916 56.1076
R1373 VDPWR.n1081 VDPWR.n925 56.1076
R1374 VDPWR.n1081 VDPWR.n915 56.1076
R1375 VDPWR.n1081 VDPWR.n914 56.1076
R1376 VDPWR.n1081 VDPWR.n926 56.1076
R1377 VDPWR.n1081 VDPWR.n913 56.1076
R1378 VDPWR.n1081 VDPWR.n927 56.1076
R1379 VDPWR.n1081 VDPWR.n928 56.1076
R1380 VDPWR.n1081 VDPWR.n929 56.1076
R1381 VDPWR.n1081 VDPWR.n930 56.1076
R1382 VDPWR.n1081 VDPWR.n931 56.1076
R1383 VDPWR.n1081 VDPWR.n933 56.1076
R1384 VDPWR.n1081 VDPWR.n911 56.1076
R1385 VDPWR.n1081 VDPWR.n910 56.1076
R1386 VDPWR.n1081 VDPWR.n934 56.1076
R1387 VDPWR.n1081 VDPWR.n909 56.1076
R1388 VDPWR.n1081 VDPWR.n908 56.1076
R1389 VDPWR.n1081 VDPWR.n907 56.1076
R1390 VDPWR.n1081 VDPWR.n906 56.1076
R1391 VDPWR.n1081 VDPWR.n935 56.1076
R1392 VDPWR.n1081 VDPWR.n904 56.1076
R1393 VDPWR.n1081 VDPWR.n936 56.1076
R1394 VDPWR.n1081 VDPWR.n937 56.1076
R1395 VDPWR.n1081 VDPWR.n939 56.1076
R1396 VDPWR.n1081 VDPWR.n903 56.1076
R1397 VDPWR.n1081 VDPWR.n902 56.1076
R1398 VDPWR.n1081 VDPWR.n1080 56.1076
R1399 VDPWR.n714 VDPWR.n711 56.1076
R1400 VDPWR.n880 VDPWR.n711 56.1076
R1401 VDPWR.n874 VDPWR.n711 56.1076
R1402 VDPWR.n871 VDPWR.n711 56.1076
R1403 VDPWR.n865 VDPWR.n711 56.1076
R1404 VDPWR.n862 VDPWR.n711 56.1076
R1405 VDPWR.n723 VDPWR.n711 56.1076
R1406 VDPWR.n855 VDPWR.n711 56.1076
R1407 VDPWR.n849 VDPWR.n711 56.1076
R1408 VDPWR.n728 VDPWR.n711 56.1076
R1409 VDPWR.n841 VDPWR.n711 56.1076
R1410 VDPWR.n731 VDPWR.n711 56.1076
R1411 VDPWR.n833 VDPWR.n711 56.1076
R1412 VDPWR.n827 VDPWR.n711 56.1076
R1413 VDPWR.n824 VDPWR.n711 56.1076
R1414 VDPWR.n738 VDPWR.n711 56.1076
R1415 VDPWR.n817 VDPWR.n711 56.1076
R1416 VDPWR.n741 VDPWR.n711 56.1076
R1417 VDPWR.n809 VDPWR.n711 56.1076
R1418 VDPWR.n745 VDPWR.n711 56.1076
R1419 VDPWR.n802 VDPWR.n711 56.1076
R1420 VDPWR.n748 VDPWR.n711 56.1076
R1421 VDPWR.n795 VDPWR.n711 56.1076
R1422 VDPWR.n751 VDPWR.n711 56.1076
R1423 VDPWR.n788 VDPWR.n711 56.1076
R1424 VDPWR.n754 VDPWR.n711 56.1076
R1425 VDPWR.n780 VDPWR.n711 56.1076
R1426 VDPWR.n774 VDPWR.n711 56.1076
R1427 VDPWR.n771 VDPWR.n711 56.1076
R1428 VDPWR.n761 VDPWR.n711 56.1076
R1429 VDPWR.n763 VDPWR.n711 56.1076
R1430 VDPWR.n399 VDPWR.n398 55.3087
R1431 VDPWR.n399 VDPWR.n307 55.3087
R1432 VDPWR.n405 VDPWR.n307 55.3087
R1433 VDPWR.n355 VDPWR.n354 55.3087
R1434 VDPWR.n355 VDPWR.n312 55.3087
R1435 VDPWR.n348 VDPWR.n312 55.3087
R1436 VDPWR.n505 VDPWR.n504 55.3087
R1437 VDPWR.n505 VDPWR.n413 55.3087
R1438 VDPWR.n511 VDPWR.n413 55.3087
R1439 VDPWR.n461 VDPWR.n460 55.3087
R1440 VDPWR.n461 VDPWR.n418 55.3087
R1441 VDPWR.n454 VDPWR.n418 55.3087
R1442 VDPWR.t9 VDPWR.n532 51.3519
R1443 VDPWR.t14 VDPWR.n623 51.3519
R1444 VDPWR.n49 VDPWR.t12 42.0578
R1445 VDPWR.n17 VDPWR.t12 42.0578
R1446 VDPWR.n97 VDPWR.t15 42.0578
R1447 VDPWR.n65 VDPWR.t15 42.0578
R1448 VDPWR.n144 VDPWR.t10 42.0578
R1449 VDPWR.n112 VDPWR.t10 42.0578
R1450 VDPWR.n405 VDPWR.t7 27.6546
R1451 VDPWR.n354 VDPWR.t7 27.6546
R1452 VDPWR.n511 VDPWR.t5 27.6546
R1453 VDPWR.n460 VDPWR.t5 27.6546
R1454 VDPWR.n35 VDPWR.n7 25.6005
R1455 VDPWR.n39 VDPWR.n35 25.6005
R1456 VDPWR.n40 VDPWR.n39 25.6005
R1457 VDPWR.n40 VDPWR.n33 25.6005
R1458 VDPWR.n45 VDPWR.n33 25.6005
R1459 VDPWR.n46 VDPWR.n45 25.6005
R1460 VDPWR.n47 VDPWR.n32 25.6005
R1461 VDPWR.n26 VDPWR.n25 25.6005
R1462 VDPWR.n25 VDPWR.n24 25.6005
R1463 VDPWR.n24 VDPWR.n21 25.6005
R1464 VDPWR.n21 VDPWR.n20 25.6005
R1465 VDPWR.n20 VDPWR.n13 25.6005
R1466 VDPWR.n31 VDPWR.n13 25.6005
R1467 VDPWR.n83 VDPWR.n55 25.6005
R1468 VDPWR.n87 VDPWR.n83 25.6005
R1469 VDPWR.n88 VDPWR.n87 25.6005
R1470 VDPWR.n88 VDPWR.n81 25.6005
R1471 VDPWR.n93 VDPWR.n81 25.6005
R1472 VDPWR.n94 VDPWR.n93 25.6005
R1473 VDPWR.n95 VDPWR.n80 25.6005
R1474 VDPWR.n74 VDPWR.n73 25.6005
R1475 VDPWR.n73 VDPWR.n72 25.6005
R1476 VDPWR.n72 VDPWR.n69 25.6005
R1477 VDPWR.n69 VDPWR.n68 25.6005
R1478 VDPWR.n68 VDPWR.n61 25.6005
R1479 VDPWR.n79 VDPWR.n61 25.6005
R1480 VDPWR.n130 VDPWR.n102 25.6005
R1481 VDPWR.n134 VDPWR.n130 25.6005
R1482 VDPWR.n135 VDPWR.n134 25.6005
R1483 VDPWR.n135 VDPWR.n128 25.6005
R1484 VDPWR.n140 VDPWR.n128 25.6005
R1485 VDPWR.n141 VDPWR.n140 25.6005
R1486 VDPWR.n142 VDPWR.n127 25.6005
R1487 VDPWR.n121 VDPWR.n120 25.6005
R1488 VDPWR.n120 VDPWR.n119 25.6005
R1489 VDPWR.n119 VDPWR.n116 25.6005
R1490 VDPWR.n116 VDPWR.n115 25.6005
R1491 VDPWR.n115 VDPWR.n108 25.6005
R1492 VDPWR.n126 VDPWR.n108 25.6005
R1493 VDPWR.n198 VDPWR.n197 25.6005
R1494 VDPWR.n198 VDPWR.n148 25.6005
R1495 VDPWR.n185 VDPWR.n150 25.6005
R1496 VDPWR.n186 VDPWR.n185 25.6005
R1497 VDPWR.n186 VDPWR.n184 25.6005
R1498 VDPWR.n184 VDPWR.n183 25.6005
R1499 VDPWR.n183 VDPWR.n160 25.6005
R1500 VDPWR.n173 VDPWR.n160 25.6005
R1501 VDPWR.n172 VDPWR.n171 25.6005
R1502 VDPWR.n171 VDPWR.n165 25.6005
R1503 VDPWR.n192 VDPWR.n191 25.6005
R1504 VDPWR.n191 VDPWR.n190 25.6005
R1505 VDPWR.n190 VDPWR.n157 25.6005
R1506 VDPWR.n179 VDPWR.n157 25.6005
R1507 VDPWR.n179 VDPWR.n178 25.6005
R1508 VDPWR.n178 VDPWR.n177 25.6005
R1509 VDPWR.n250 VDPWR.n249 25.6005
R1510 VDPWR.n250 VDPWR.n200 25.6005
R1511 VDPWR.n237 VDPWR.n202 25.6005
R1512 VDPWR.n238 VDPWR.n237 25.6005
R1513 VDPWR.n238 VDPWR.n236 25.6005
R1514 VDPWR.n236 VDPWR.n235 25.6005
R1515 VDPWR.n235 VDPWR.n212 25.6005
R1516 VDPWR.n225 VDPWR.n212 25.6005
R1517 VDPWR.n224 VDPWR.n223 25.6005
R1518 VDPWR.n223 VDPWR.n217 25.6005
R1519 VDPWR.n244 VDPWR.n243 25.6005
R1520 VDPWR.n243 VDPWR.n242 25.6005
R1521 VDPWR.n242 VDPWR.n209 25.6005
R1522 VDPWR.n231 VDPWR.n209 25.6005
R1523 VDPWR.n231 VDPWR.n230 25.6005
R1524 VDPWR.n230 VDPWR.n229 25.6005
R1525 VDPWR.n302 VDPWR.n301 25.6005
R1526 VDPWR.n302 VDPWR.n252 25.6005
R1527 VDPWR.n289 VDPWR.n254 25.6005
R1528 VDPWR.n290 VDPWR.n289 25.6005
R1529 VDPWR.n290 VDPWR.n288 25.6005
R1530 VDPWR.n288 VDPWR.n287 25.6005
R1531 VDPWR.n287 VDPWR.n264 25.6005
R1532 VDPWR.n277 VDPWR.n264 25.6005
R1533 VDPWR.n276 VDPWR.n275 25.6005
R1534 VDPWR.n275 VDPWR.n269 25.6005
R1535 VDPWR.n296 VDPWR.n295 25.6005
R1536 VDPWR.n295 VDPWR.n294 25.6005
R1537 VDPWR.n294 VDPWR.n261 25.6005
R1538 VDPWR.n283 VDPWR.n261 25.6005
R1539 VDPWR.n283 VDPWR.n282 25.6005
R1540 VDPWR.n282 VDPWR.n281 25.6005
R1541 VDPWR.n371 VDPWR.n370 25.6005
R1542 VDPWR.n370 VDPWR.n304 25.6005
R1543 VDPWR.n407 VDPWR.n304 25.6005
R1544 VDPWR.n352 VDPWR.n303 25.6005
R1545 VDPWR.n352 VDPWR.n351 25.6005
R1546 VDPWR.n351 VDPWR.n350 25.6005
R1547 VDPWR.n374 VDPWR.n373 25.6005
R1548 VDPWR.n377 VDPWR.n374 25.6005
R1549 VDPWR.n378 VDPWR.n377 25.6005
R1550 VDPWR.n381 VDPWR.n378 25.6005
R1551 VDPWR.n383 VDPWR.n381 25.6005
R1552 VDPWR.n384 VDPWR.n383 25.6005
R1553 VDPWR.n386 VDPWR.n384 25.6005
R1554 VDPWR.n387 VDPWR.n386 25.6005
R1555 VDPWR.n390 VDPWR.n387 25.6005
R1556 VDPWR.n392 VDPWR.n390 25.6005
R1557 VDPWR.n393 VDPWR.n392 25.6005
R1558 VDPWR.n394 VDPWR.n393 25.6005
R1559 VDPWR.n401 VDPWR.n359 25.6005
R1560 VDPWR.n402 VDPWR.n401 25.6005
R1561 VDPWR.n403 VDPWR.n402 25.6005
R1562 VDPWR.n403 VDPWR.n358 25.6005
R1563 VDPWR.n358 VDPWR.n357 25.6005
R1564 VDPWR.n357 VDPWR.n310 25.6005
R1565 VDPWR.n346 VDPWR.n310 25.6005
R1566 VDPWR.n325 VDPWR.n314 25.6005
R1567 VDPWR.n325 VDPWR.n323 25.6005
R1568 VDPWR.n330 VDPWR.n323 25.6005
R1569 VDPWR.n331 VDPWR.n330 25.6005
R1570 VDPWR.n332 VDPWR.n331 25.6005
R1571 VDPWR.n332 VDPWR.n320 25.6005
R1572 VDPWR.n337 VDPWR.n320 25.6005
R1573 VDPWR.n338 VDPWR.n337 25.6005
R1574 VDPWR.n339 VDPWR.n338 25.6005
R1575 VDPWR.n339 VDPWR.n318 25.6005
R1576 VDPWR.n344 VDPWR.n318 25.6005
R1577 VDPWR.n345 VDPWR.n344 25.6005
R1578 VDPWR.n477 VDPWR.n476 25.6005
R1579 VDPWR.n476 VDPWR.n410 25.6005
R1580 VDPWR.n513 VDPWR.n410 25.6005
R1581 VDPWR.n458 VDPWR.n409 25.6005
R1582 VDPWR.n458 VDPWR.n457 25.6005
R1583 VDPWR.n457 VDPWR.n456 25.6005
R1584 VDPWR.n481 VDPWR.n479 25.6005
R1585 VDPWR.n482 VDPWR.n481 25.6005
R1586 VDPWR.n484 VDPWR.n482 25.6005
R1587 VDPWR.n485 VDPWR.n484 25.6005
R1588 VDPWR.n488 VDPWR.n485 25.6005
R1589 VDPWR.n489 VDPWR.n488 25.6005
R1590 VDPWR.n492 VDPWR.n489 25.6005
R1591 VDPWR.n493 VDPWR.n492 25.6005
R1592 VDPWR.n496 VDPWR.n493 25.6005
R1593 VDPWR.n498 VDPWR.n496 25.6005
R1594 VDPWR.n499 VDPWR.n498 25.6005
R1595 VDPWR.n500 VDPWR.n499 25.6005
R1596 VDPWR.n507 VDPWR.n465 25.6005
R1597 VDPWR.n508 VDPWR.n507 25.6005
R1598 VDPWR.n509 VDPWR.n508 25.6005
R1599 VDPWR.n509 VDPWR.n464 25.6005
R1600 VDPWR.n464 VDPWR.n463 25.6005
R1601 VDPWR.n463 VDPWR.n416 25.6005
R1602 VDPWR.n452 VDPWR.n416 25.6005
R1603 VDPWR.n434 VDPWR.n420 25.6005
R1604 VDPWR.n435 VDPWR.n434 25.6005
R1605 VDPWR.n436 VDPWR.n435 25.6005
R1606 VDPWR.n436 VDPWR.n430 25.6005
R1607 VDPWR.n430 VDPWR.n428 25.6005
R1608 VDPWR.n442 VDPWR.n428 25.6005
R1609 VDPWR.n443 VDPWR.n442 25.6005
R1610 VDPWR.n444 VDPWR.n443 25.6005
R1611 VDPWR.n444 VDPWR.n426 25.6005
R1612 VDPWR.n426 VDPWR.n424 25.6005
R1613 VDPWR.n450 VDPWR.n424 25.6005
R1614 VDPWR.n451 VDPWR.n450 25.6005
R1615 VDPWR.n604 VDPWR.n517 25.6005
R1616 VDPWR.n605 VDPWR.n604 25.6005
R1617 VDPWR.n605 VDPWR.n515 25.6005
R1618 VDPWR.n596 VDPWR.n515 25.6005
R1619 VDPWR.n589 VDPWR.n520 25.6005
R1620 VDPWR.n590 VDPWR.n589 25.6005
R1621 VDPWR.n590 VDPWR.n588 25.6005
R1622 VDPWR.n588 VDPWR.n587 25.6005
R1623 VDPWR.n587 VDPWR.n530 25.6005
R1624 VDPWR.n577 VDPWR.n530 25.6005
R1625 VDPWR.n577 VDPWR.n576 25.6005
R1626 VDPWR.n576 VDPWR.n575 25.6005
R1627 VDPWR.n575 VDPWR.n538 25.6005
R1628 VDPWR.n565 VDPWR.n538 25.6005
R1629 VDPWR.n565 VDPWR.n564 25.6005
R1630 VDPWR.n564 VDPWR.n563 25.6005
R1631 VDPWR.n552 VDPWR.n546 25.6005
R1632 VDPWR.n552 VDPWR.n550 25.6005
R1633 VDPWR.n557 VDPWR.n550 25.6005
R1634 VDPWR.n558 VDPWR.n557 25.6005
R1635 VDPWR.n597 VDPWR.n595 25.6005
R1636 VDPWR.n595 VDPWR.n594 25.6005
R1637 VDPWR.n594 VDPWR.n526 25.6005
R1638 VDPWR.n583 VDPWR.n526 25.6005
R1639 VDPWR.n583 VDPWR.n582 25.6005
R1640 VDPWR.n582 VDPWR.n581 25.6005
R1641 VDPWR.n581 VDPWR.n534 25.6005
R1642 VDPWR.n571 VDPWR.n534 25.6005
R1643 VDPWR.n571 VDPWR.n570 25.6005
R1644 VDPWR.n570 VDPWR.n569 25.6005
R1645 VDPWR.n569 VDPWR.n542 25.6005
R1646 VDPWR.n559 VDPWR.n542 25.6005
R1647 VDPWR.n695 VDPWR.n608 25.6005
R1648 VDPWR.n696 VDPWR.n695 25.6005
R1649 VDPWR.n696 VDPWR.n606 25.6005
R1650 VDPWR.n687 VDPWR.n606 25.6005
R1651 VDPWR.n680 VDPWR.n611 25.6005
R1652 VDPWR.n681 VDPWR.n680 25.6005
R1653 VDPWR.n681 VDPWR.n679 25.6005
R1654 VDPWR.n679 VDPWR.n678 25.6005
R1655 VDPWR.n678 VDPWR.n621 25.6005
R1656 VDPWR.n668 VDPWR.n621 25.6005
R1657 VDPWR.n668 VDPWR.n667 25.6005
R1658 VDPWR.n667 VDPWR.n666 25.6005
R1659 VDPWR.n666 VDPWR.n629 25.6005
R1660 VDPWR.n656 VDPWR.n629 25.6005
R1661 VDPWR.n656 VDPWR.n655 25.6005
R1662 VDPWR.n655 VDPWR.n654 25.6005
R1663 VDPWR.n643 VDPWR.n637 25.6005
R1664 VDPWR.n643 VDPWR.n641 25.6005
R1665 VDPWR.n648 VDPWR.n641 25.6005
R1666 VDPWR.n649 VDPWR.n648 25.6005
R1667 VDPWR.n688 VDPWR.n686 25.6005
R1668 VDPWR.n686 VDPWR.n685 25.6005
R1669 VDPWR.n685 VDPWR.n617 25.6005
R1670 VDPWR.n674 VDPWR.n617 25.6005
R1671 VDPWR.n674 VDPWR.n673 25.6005
R1672 VDPWR.n673 VDPWR.n672 25.6005
R1673 VDPWR.n672 VDPWR.n625 25.6005
R1674 VDPWR.n662 VDPWR.n625 25.6005
R1675 VDPWR.n662 VDPWR.n661 25.6005
R1676 VDPWR.n661 VDPWR.n660 25.6005
R1677 VDPWR.n660 VDPWR.n633 25.6005
R1678 VDPWR.n650 VDPWR.n633 25.6005
R1679 VDPWR.n942 VDPWR.n941 25.6005
R1680 VDPWR.n941 VDPWR.n699 25.6005
R1681 VDPWR.n1091 VDPWR.n699 25.6005
R1682 VDPWR.n891 VDPWR.n698 25.6005
R1683 VDPWR.n891 VDPWR.n890 25.6005
R1684 VDPWR.n890 VDPWR.n889 25.6005
R1685 VDPWR.n945 VDPWR.n944 25.6005
R1686 VDPWR.n948 VDPWR.n945 25.6005
R1687 VDPWR.n949 VDPWR.n948 25.6005
R1688 VDPWR.n952 VDPWR.n949 25.6005
R1689 VDPWR.n953 VDPWR.n952 25.6005
R1690 VDPWR.n956 VDPWR.n953 25.6005
R1691 VDPWR.n958 VDPWR.n956 25.6005
R1692 VDPWR.n959 VDPWR.n958 25.6005
R1693 VDPWR.n961 VDPWR.n959 25.6005
R1694 VDPWR.n962 VDPWR.n961 25.6005
R1695 VDPWR.n965 VDPWR.n962 25.6005
R1696 VDPWR.n967 VDPWR.n965 25.6005
R1697 VDPWR.n968 VDPWR.n967 25.6005
R1698 VDPWR.n970 VDPWR.n968 25.6005
R1699 VDPWR.n971 VDPWR.n970 25.6005
R1700 VDPWR.n974 VDPWR.n971 25.6005
R1701 VDPWR.n975 VDPWR.n974 25.6005
R1702 VDPWR.n978 VDPWR.n975 25.6005
R1703 VDPWR.n979 VDPWR.n978 25.6005
R1704 VDPWR.n982 VDPWR.n979 25.6005
R1705 VDPWR.n983 VDPWR.n982 25.6005
R1706 VDPWR.n986 VDPWR.n983 25.6005
R1707 VDPWR.n987 VDPWR.n986 25.6005
R1708 VDPWR.n990 VDPWR.n987 25.6005
R1709 VDPWR.n992 VDPWR.n990 25.6005
R1710 VDPWR.n993 VDPWR.n992 25.6005
R1711 VDPWR.n995 VDPWR.n993 25.6005
R1712 VDPWR.n996 VDPWR.n995 25.6005
R1713 VDPWR.n999 VDPWR.n996 25.6005
R1714 VDPWR.n1000 VDPWR.n999 25.6005
R1715 VDPWR.n1003 VDPWR.n1000 25.6005
R1716 VDPWR.n1004 VDPWR.n1003 25.6005
R1717 VDPWR.n1007 VDPWR.n1004 25.6005
R1718 VDPWR.n1008 VDPWR.n1007 25.6005
R1719 VDPWR.n1011 VDPWR.n1008 25.6005
R1720 VDPWR.n1013 VDPWR.n1011 25.6005
R1721 VDPWR.n1014 VDPWR.n1013 25.6005
R1722 VDPWR.n1016 VDPWR.n1014 25.6005
R1723 VDPWR.n1017 VDPWR.n1016 25.6005
R1724 VDPWR.n1020 VDPWR.n1017 25.6005
R1725 VDPWR.n1021 VDPWR.n1020 25.6005
R1726 VDPWR.n1024 VDPWR.n1021 25.6005
R1727 VDPWR.n1025 VDPWR.n1024 25.6005
R1728 VDPWR.n1028 VDPWR.n1025 25.6005
R1729 VDPWR.n1029 VDPWR.n1028 25.6005
R1730 VDPWR.n1032 VDPWR.n1029 25.6005
R1731 VDPWR.n1033 VDPWR.n1032 25.6005
R1732 VDPWR.n1036 VDPWR.n1033 25.6005
R1733 VDPWR.n1037 VDPWR.n1036 25.6005
R1734 VDPWR.n1040 VDPWR.n1037 25.6005
R1735 VDPWR.n1041 VDPWR.n1040 25.6005
R1736 VDPWR.n1044 VDPWR.n1041 25.6005
R1737 VDPWR.n1046 VDPWR.n1044 25.6005
R1738 VDPWR.n1047 VDPWR.n1046 25.6005
R1739 VDPWR.n1049 VDPWR.n1047 25.6005
R1740 VDPWR.n1050 VDPWR.n1049 25.6005
R1741 VDPWR.n1053 VDPWR.n1050 25.6005
R1742 VDPWR.n1054 VDPWR.n1053 25.6005
R1743 VDPWR.n1057 VDPWR.n1054 25.6005
R1744 VDPWR.n1058 VDPWR.n1057 25.6005
R1745 VDPWR.n1061 VDPWR.n1058 25.6005
R1746 VDPWR.n1063 VDPWR.n1061 25.6005
R1747 VDPWR.n1064 VDPWR.n1063 25.6005
R1748 VDPWR.n1066 VDPWR.n1064 25.6005
R1749 VDPWR.n1067 VDPWR.n1066 25.6005
R1750 VDPWR.n1070 VDPWR.n1067 25.6005
R1751 VDPWR.n1071 VDPWR.n1070 25.6005
R1752 VDPWR.n1074 VDPWR.n1071 25.6005
R1753 VDPWR.n1076 VDPWR.n1074 25.6005
R1754 VDPWR.n1077 VDPWR.n1076 25.6005
R1755 VDPWR.n1078 VDPWR.n1077 25.6005
R1756 VDPWR.n1085 VDPWR.n898 25.6005
R1757 VDPWR.n1086 VDPWR.n1085 25.6005
R1758 VDPWR.n1087 VDPWR.n1086 25.6005
R1759 VDPWR.n1087 VDPWR.n897 25.6005
R1760 VDPWR.n897 VDPWR.n896 25.6005
R1761 VDPWR.n896 VDPWR.n705 25.6005
R1762 VDPWR.n885 VDPWR.n705 25.6005
R1763 VDPWR.n762 VDPWR.n709 25.6005
R1764 VDPWR.n762 VDPWR.n760 25.6005
R1765 VDPWR.n767 VDPWR.n760 25.6005
R1766 VDPWR.n768 VDPWR.n767 25.6005
R1767 VDPWR.n769 VDPWR.n768 25.6005
R1768 VDPWR.n769 VDPWR.n758 25.6005
R1769 VDPWR.n758 VDPWR.n757 25.6005
R1770 VDPWR.n776 VDPWR.n757 25.6005
R1771 VDPWR.n777 VDPWR.n776 25.6005
R1772 VDPWR.n778 VDPWR.n777 25.6005
R1773 VDPWR.n778 VDPWR.n755 25.6005
R1774 VDPWR.n755 VDPWR.n753 25.6005
R1775 VDPWR.n784 VDPWR.n753 25.6005
R1776 VDPWR.n785 VDPWR.n784 25.6005
R1777 VDPWR.n786 VDPWR.n785 25.6005
R1778 VDPWR.n786 VDPWR.n750 25.6005
R1779 VDPWR.n791 VDPWR.n750 25.6005
R1780 VDPWR.n792 VDPWR.n791 25.6005
R1781 VDPWR.n793 VDPWR.n792 25.6005
R1782 VDPWR.n793 VDPWR.n747 25.6005
R1783 VDPWR.n798 VDPWR.n747 25.6005
R1784 VDPWR.n799 VDPWR.n798 25.6005
R1785 VDPWR.n800 VDPWR.n799 25.6005
R1786 VDPWR.n800 VDPWR.n744 25.6005
R1787 VDPWR.n805 VDPWR.n744 25.6005
R1788 VDPWR.n806 VDPWR.n805 25.6005
R1789 VDPWR.n807 VDPWR.n806 25.6005
R1790 VDPWR.n807 VDPWR.n742 25.6005
R1791 VDPWR.n742 VDPWR.n740 25.6005
R1792 VDPWR.n813 VDPWR.n740 25.6005
R1793 VDPWR.n814 VDPWR.n813 25.6005
R1794 VDPWR.n815 VDPWR.n814 25.6005
R1795 VDPWR.n815 VDPWR.n737 25.6005
R1796 VDPWR.n820 VDPWR.n737 25.6005
R1797 VDPWR.n821 VDPWR.n820 25.6005
R1798 VDPWR.n822 VDPWR.n821 25.6005
R1799 VDPWR.n822 VDPWR.n735 25.6005
R1800 VDPWR.n735 VDPWR.n734 25.6005
R1801 VDPWR.n829 VDPWR.n734 25.6005
R1802 VDPWR.n830 VDPWR.n829 25.6005
R1803 VDPWR.n831 VDPWR.n830 25.6005
R1804 VDPWR.n831 VDPWR.n732 25.6005
R1805 VDPWR.n732 VDPWR.n730 25.6005
R1806 VDPWR.n837 VDPWR.n730 25.6005
R1807 VDPWR.n838 VDPWR.n837 25.6005
R1808 VDPWR.n839 VDPWR.n838 25.6005
R1809 VDPWR.n839 VDPWR.n727 25.6005
R1810 VDPWR.n844 VDPWR.n727 25.6005
R1811 VDPWR.n845 VDPWR.n844 25.6005
R1812 VDPWR.n846 VDPWR.n845 25.6005
R1813 VDPWR.n846 VDPWR.n725 25.6005
R1814 VDPWR.n851 VDPWR.n725 25.6005
R1815 VDPWR.n852 VDPWR.n851 25.6005
R1816 VDPWR.n853 VDPWR.n852 25.6005
R1817 VDPWR.n853 VDPWR.n722 25.6005
R1818 VDPWR.n858 VDPWR.n722 25.6005
R1819 VDPWR.n859 VDPWR.n858 25.6005
R1820 VDPWR.n860 VDPWR.n859 25.6005
R1821 VDPWR.n860 VDPWR.n720 25.6005
R1822 VDPWR.n720 VDPWR.n719 25.6005
R1823 VDPWR.n867 VDPWR.n719 25.6005
R1824 VDPWR.n868 VDPWR.n867 25.6005
R1825 VDPWR.n869 VDPWR.n868 25.6005
R1826 VDPWR.n869 VDPWR.n717 25.6005
R1827 VDPWR.n717 VDPWR.n716 25.6005
R1828 VDPWR.n876 VDPWR.n716 25.6005
R1829 VDPWR.n877 VDPWR.n876 25.6005
R1830 VDPWR.n878 VDPWR.n877 25.6005
R1831 VDPWR.n878 VDPWR.n713 25.6005
R1832 VDPWR.n883 VDPWR.n713 25.6005
R1833 VDPWR.n884 VDPWR.n883 25.6005
R1834 VDPWR.n5 VDPWR.n1092 23.9219
R1835 VDPWR.n0 VDPWR.n408 21.7344
R1836 VDPWR.n1 VDPWR.n514 21.7344
R1837 VDPWR.n1 VDPWR.n605 21.7344
R1838 VDPWR.n697 VDPWR.n696 21.7344
R1839 VDPWR.n53 VDPWR.n52 21.4219
R1840 VDPWR.n4 VDPWR.n100 21.4219
R1841 VDPWR.n3 VDPWR.n147 21.4219
R1842 VDPWR.n199 VDPWR.n198 21.4219
R1843 VDPWR.n251 VDPWR.n250 21.4219
R1844 VDPWR.n0 VDPWR.n302 21.4219
R1845 VDPWR.n1082 VDPWR.n1081 19.302
R1846 VDPWR.n887 VDPWR.n711 19.302
R1847 VDPWR.n52 VDPWR.n51 12.8005
R1848 VDPWR.n52 VDPWR.n6 12.8005
R1849 VDPWR.n100 VDPWR.n99 12.8005
R1850 VDPWR.n100 VDPWR.n54 12.8005
R1851 VDPWR.n147 VDPWR.n146 12.8005
R1852 VDPWR.n147 VDPWR.n101 12.8005
R1853 VDPWR.n408 VDPWR.n407 12.8005
R1854 VDPWR.n408 VDPWR.n303 12.8005
R1855 VDPWR.n514 VDPWR.n513 12.8005
R1856 VDPWR.n514 VDPWR.n409 12.8005
R1857 VDPWR.n1092 VDPWR.n1091 12.8005
R1858 VDPWR.n1092 VDPWR.n698 12.8005
R1859 VDPWR.n1083 VDPWR.n1082 12.5005
R1860 VDPWR.n1083 VDPWR.n702 12.5005
R1861 VDPWR.n1089 VDPWR.n702 12.5005
R1862 VDPWR.n894 VDPWR.n893 12.5005
R1863 VDPWR.n894 VDPWR.n707 12.5005
R1864 VDPWR.n887 VDPWR.n707 12.5005
R1865 VDPWR.n1089 VDPWR.t3 6.2505
R1866 VDPWR.n893 VDPWR.t3 6.2505
R1867 VDPWR.n2 VDPWR.n5 5.57772
R1868 VDPWR.n2 VDPWR 4.52425
R1869 VDPWR VDPWR.n2 3.96515
R1870 VDPWR.n2 VDPWR 3.7605
R1871 VDPWR.n5 VDPWR.n697 3.5725
R1872 VDPWR.n3 VDPWR.n4 1.72906
R1873 VDPWR.n0 VDPWR.n251 1.5515
R1874 VDPWR.n251 VDPWR.n199 1.5515
R1875 VDPWR.n199 VDPWR.n3 1.5515
R1876 VDPWR.n697 VDPWR.n1 1.53583
R1877 VDPWR.n1 VDPWR.n0 1.5045
R1878 VDPWR.n4 VDPWR.n53 1.34261
R1879 VGND.n923 VGND.n419 5142.62
R1880 VGND.n723 VGND.n26 3463.99
R1881 VGND.n419 VGND.n26 1606.94
R1882 VGND.n2049 VGND.n17 1338.44
R1883 VGND.n2030 VGND.n16 1338.44
R1884 VGND.n2047 VGND.n2024 1338.44
R1885 VGND.n2035 VGND.n2023 1338.44
R1886 VGND.n1909 VGND.n1908 1338.44
R1887 VGND.n1891 VGND.n1883 1338.44
R1888 VGND.n1904 VGND.n1886 1338.44
R1889 VGND.n1898 VGND.n1897 1338.44
R1890 VGND.n1940 VGND.n1939 1338.44
R1891 VGND.n1922 VGND.n1914 1338.44
R1892 VGND.n1935 VGND.n1917 1338.44
R1893 VGND.n1929 VGND.n1928 1338.44
R1894 VGND.n1972 VGND.n1971 1338.44
R1895 VGND.n1957 VGND.n1945 1338.44
R1896 VGND.n1967 VGND.n1948 1338.44
R1897 VGND.n1961 VGND.n1950 1338.44
R1898 VGND.n2004 VGND.n2003 1338.44
R1899 VGND.n1986 VGND.n1978 1338.44
R1900 VGND.n1999 VGND.n1981 1338.44
R1901 VGND.n1993 VGND.n1992 1338.44
R1902 VGND.n2011 VGND.n27 1338.44
R1903 VGND.n44 VGND.n43 1338.44
R1904 VGND.n2019 VGND.n30 1338.44
R1905 VGND.n35 VGND.n29 1338.44
R1906 VGND.n1878 VGND.n49 1309.47
R1907 VGND.n1429 VGND.n48 1309.47
R1908 VGND.n1876 VGND.n52 1309.47
R1909 VGND.n1628 VGND.n51 1309.47
R1910 VGND.n1188 VGND.n87 1309.47
R1911 VGND.n1187 VGND.n116 1309.47
R1912 VGND.n1375 VGND.n114 1309.47
R1913 VGND.n1185 VGND.n933 1309.47
R1914 VGND.n297 VGND.n296 1297.88
R1915 VGND.n295 VGND.n154 1297.88
R1916 VGND.n393 VGND.n151 1297.88
R1917 VGND.n293 VGND.n158 1297.88
R1918 VGND.n586 VGND.n439 1216.76
R1919 VGND.n815 VGND.n814 1216.76
R1920 VGND.n925 VGND.n399 1216.76
R1921 VGND.n589 VGND.n441 1216.76
R1922 VGND.n775 VGND.n657 1193.59
R1923 VGND.n644 VGND.n609 1193.59
R1924 VGND.n796 VGND.n655 1193.59
R1925 VGND.n642 VGND.n611 1193.59
R1926 VGND.n700 VGND.n684 1193.59
R1927 VGND.n741 VGND.n740 1193.59
R1928 VGND.n725 VGND.n683 1193.59
R1929 VGND.n765 VGND.n667 1193.59
R1930 VGND.t47 VGND.n26 935.443
R1931 VGND.n419 VGND.n50 711.614
R1932 VGND.n2027 VGND.n2026 710.418
R1933 VGND.n1906 VGND.n19 710.418
R1934 VGND.n1888 VGND.n18 710.418
R1935 VGND.n1937 VGND.n21 710.418
R1936 VGND.n1919 VGND.n20 710.418
R1937 VGND.n1969 VGND.n22 710.418
R1938 VGND.n1960 VGND.n1959 710.418
R1939 VGND.n2001 VGND.n24 710.418
R1940 VGND.n1983 VGND.n23 710.418
R1941 VGND.n2020 VGND.n28 710.418
R1942 VGND.n41 VGND.n25 710.418
R1943 VGND.n2022 VGND.t52 604.822
R1944 VGND.n798 VGND.n766 598.529
R1945 VGND.n2021 VGND.t54 595.718
R1946 VGND.t52 VGND.t45 593.74
R1947 VGND.t54 VGND.t47 593.74
R1948 VGND.t45 VGND.n2021 591.76
R1949 VGND.n440 VGND.n439 585
R1950 VGND.n584 VGND.n439 585
R1951 VGND.n595 VGND.n594 585
R1952 VGND.n595 VGND.n438 585
R1953 VGND.n596 VGND.t0 585
R1954 VGND.n811 VGND.n596 585
R1955 VGND.n930 VGND.n396 585
R1956 VGND.n812 VGND.n396 585
R1957 VGND.n814 VGND.n397 585
R1958 VGND.n814 VGND.n813 585
R1959 VGND.n816 VGND.n815 585
R1960 VGND.n818 VGND.n817 585
R1961 VGND.n820 VGND.n819 585
R1962 VGND.n822 VGND.n821 585
R1963 VGND.n923 VGND.n416 585
R1964 VGND.n823 VGND.n416 585
R1965 VGND.n825 VGND.n824 585
R1966 VGND.n827 VGND.n826 585
R1967 VGND.n829 VGND.n828 585
R1968 VGND.n831 VGND.n830 585
R1969 VGND.n923 VGND.n422 585
R1970 VGND.n832 VGND.n422 585
R1971 VGND.n834 VGND.n833 585
R1972 VGND.n836 VGND.n835 585
R1973 VGND.n838 VGND.n837 585
R1974 VGND.n840 VGND.n839 585
R1975 VGND.n842 VGND.n841 585
R1976 VGND.n844 VGND.n843 585
R1977 VGND.n923 VGND.n412 585
R1978 VGND.n845 VGND.n412 585
R1979 VGND.n847 VGND.n846 585
R1980 VGND.n849 VGND.n848 585
R1981 VGND.n851 VGND.n850 585
R1982 VGND.n853 VGND.n852 585
R1983 VGND.n855 VGND.n854 585
R1984 VGND.n857 VGND.n856 585
R1985 VGND.n859 VGND.n858 585
R1986 VGND.n861 VGND.n860 585
R1987 VGND.n923 VGND.n425 585
R1988 VGND.n862 VGND.n425 585
R1989 VGND.n864 VGND.n863 585
R1990 VGND.n866 VGND.n865 585
R1991 VGND.n923 VGND.n408 585
R1992 VGND.n867 VGND.n408 585
R1993 VGND.n869 VGND.n868 585
R1994 VGND.n871 VGND.n870 585
R1995 VGND.n873 VGND.n872 585
R1996 VGND.n875 VGND.n874 585
R1997 VGND.n877 VGND.n876 585
R1998 VGND.n879 VGND.n878 585
R1999 VGND.n881 VGND.n880 585
R2000 VGND.n883 VGND.n882 585
R2001 VGND.n885 VGND.n884 585
R2002 VGND.n887 VGND.n886 585
R2003 VGND.n889 VGND.n888 585
R2004 VGND.n891 VGND.n890 585
R2005 VGND.n893 VGND.n892 585
R2006 VGND.n895 VGND.n894 585
R2007 VGND.n897 VGND.n896 585
R2008 VGND.n899 VGND.n898 585
R2009 VGND.n901 VGND.n900 585
R2010 VGND.n903 VGND.n902 585
R2011 VGND.n905 VGND.n904 585
R2012 VGND.n907 VGND.n906 585
R2013 VGND.n923 VGND.n433 585
R2014 VGND.n908 VGND.n433 585
R2015 VGND.n910 VGND.n909 585
R2016 VGND.n912 VGND.n911 585
R2017 VGND.n914 VGND.n913 585
R2018 VGND.n916 VGND.n915 585
R2019 VGND.n918 VGND.n917 585
R2020 VGND.n919 VGND.n436 585
R2021 VGND.n921 VGND.n920 585
R2022 VGND.n437 VGND.n435 585
R2023 VGND.n402 VGND.n401 585
R2024 VGND.n926 VGND.n925 585
R2025 VGND.n399 VGND.n397 585
R2026 VGND.n927 VGND.n399 585
R2027 VGND.n930 VGND.n929 585
R2028 VGND.n929 VGND.n928 585
R2029 VGND.n398 VGND.t0 585
R2030 VGND.n400 VGND.n398 585
R2031 VGND.n594 VGND.n593 585
R2032 VGND.n593 VGND.n592 585
R2033 VGND.n441 VGND.n440 585
R2034 VGND.n591 VGND.n441 585
R2035 VGND.n589 VGND.n588 585
R2036 VGND.n590 VGND.n589 585
R2037 VGND.n443 VGND.n442 585
R2038 VGND.n477 VGND.n476 585
R2039 VGND.n479 VGND.n478 585
R2040 VGND.n481 VGND.n480 585
R2041 VGND.n588 VGND.n446 585
R2042 VGND.n482 VGND.n446 585
R2043 VGND.n484 VGND.n483 585
R2044 VGND.n486 VGND.n485 585
R2045 VGND.n488 VGND.n487 585
R2046 VGND.n490 VGND.n489 585
R2047 VGND.n588 VGND.n449 585
R2048 VGND.n491 VGND.n449 585
R2049 VGND.n493 VGND.n492 585
R2050 VGND.n495 VGND.n494 585
R2051 VGND.n497 VGND.n496 585
R2052 VGND.n499 VGND.n498 585
R2053 VGND.n501 VGND.n500 585
R2054 VGND.n503 VGND.n502 585
R2055 VGND.n505 VGND.n504 585
R2056 VGND.n507 VGND.n506 585
R2057 VGND.n509 VGND.n508 585
R2058 VGND.n511 VGND.n510 585
R2059 VGND.n513 VGND.n512 585
R2060 VGND.n515 VGND.n514 585
R2061 VGND.n517 VGND.n516 585
R2062 VGND.n519 VGND.n518 585
R2063 VGND.n521 VGND.n520 585
R2064 VGND.n523 VGND.n522 585
R2065 VGND.n525 VGND.n524 585
R2066 VGND.n527 VGND.n526 585
R2067 VGND.n529 VGND.n528 585
R2068 VGND.n531 VGND.n530 585
R2069 VGND.n533 VGND.n532 585
R2070 VGND.n535 VGND.n534 585
R2071 VGND.n537 VGND.n536 585
R2072 VGND.n539 VGND.n538 585
R2073 VGND.n541 VGND.n540 585
R2074 VGND.n543 VGND.n542 585
R2075 VGND.n588 VGND.n463 585
R2076 VGND.n544 VGND.n463 585
R2077 VGND.n546 VGND.n545 585
R2078 VGND.n548 VGND.n547 585
R2079 VGND.n550 VGND.n549 585
R2080 VGND.n552 VGND.n551 585
R2081 VGND.n554 VGND.n553 585
R2082 VGND.n556 VGND.n555 585
R2083 VGND.n558 VGND.n557 585
R2084 VGND.n560 VGND.n559 585
R2085 VGND.n588 VGND.n468 585
R2086 VGND.n561 VGND.n468 585
R2087 VGND.n563 VGND.n562 585
R2088 VGND.n565 VGND.n564 585
R2089 VGND.n567 VGND.n566 585
R2090 VGND.n569 VGND.n568 585
R2091 VGND.n571 VGND.n570 585
R2092 VGND.n573 VGND.n572 585
R2093 VGND.n575 VGND.n574 585
R2094 VGND.n577 VGND.n576 585
R2095 VGND.n588 VGND.n473 585
R2096 VGND.n578 VGND.n473 585
R2097 VGND.n580 VGND.n579 585
R2098 VGND.n582 VGND.n581 585
R2099 VGND.n583 VGND.n475 585
R2100 VGND.n586 VGND.n585 585
R2101 VGND.n114 VGND.n55 585
R2102 VGND.n115 VGND.n114 585
R2103 VGND.n1186 VGND.n1185 585
R2104 VGND.n1185 VGND.n1184 585
R2105 VGND.n933 VGND.n932 585
R2106 VGND.n1183 VGND.n933 585
R2107 VGND.n1182 VGND.n1181 585
R2108 VGND.n1179 VGND.n934 585
R2109 VGND.n1178 VGND.n935 585
R2110 VGND.n1176 VGND.n1175 585
R2111 VGND.n1174 VGND.n936 585
R2112 VGND.n1173 VGND.n1172 585
R2113 VGND.n1171 VGND.n937 585
R2114 VGND.n1169 VGND.n1168 585
R2115 VGND.n1167 VGND.n939 585
R2116 VGND.n1166 VGND.n1165 585
R2117 VGND.n1164 VGND.n940 585
R2118 VGND.n1162 VGND.n1161 585
R2119 VGND.n1160 VGND.n942 585
R2120 VGND.n1159 VGND.n1158 585
R2121 VGND.n1157 VGND.n943 585
R2122 VGND.n1155 VGND.n1154 585
R2123 VGND.n1153 VGND.n945 585
R2124 VGND.n1152 VGND.n1151 585
R2125 VGND.n1150 VGND.n946 585
R2126 VGND.n1148 VGND.n1147 585
R2127 VGND.n1146 VGND.n948 585
R2128 VGND.n1145 VGND.n1144 585
R2129 VGND.n1143 VGND.n949 585
R2130 VGND.n1141 VGND.n1140 585
R2131 VGND.n1139 VGND.n951 585
R2132 VGND.n1138 VGND.n1137 585
R2133 VGND.n1136 VGND.n952 585
R2134 VGND.n1134 VGND.n1133 585
R2135 VGND.n1132 VGND.n954 585
R2136 VGND.n1131 VGND.n1130 585
R2137 VGND.n1129 VGND.n955 585
R2138 VGND.n1127 VGND.n1126 585
R2139 VGND.n1125 VGND.n957 585
R2140 VGND.n1124 VGND.n1123 585
R2141 VGND.n1122 VGND.n958 585
R2142 VGND.n1120 VGND.n1119 585
R2143 VGND.n1118 VGND.n960 585
R2144 VGND.n1117 VGND.n1116 585
R2145 VGND.n1115 VGND.n961 585
R2146 VGND.n1113 VGND.n1112 585
R2147 VGND.n1111 VGND.n963 585
R2148 VGND.n1110 VGND.n1109 585
R2149 VGND.n1108 VGND.n964 585
R2150 VGND.n1106 VGND.n1105 585
R2151 VGND.n1104 VGND.n966 585
R2152 VGND.n1103 VGND.n1102 585
R2153 VGND.n1101 VGND.n967 585
R2154 VGND.n1099 VGND.n1098 585
R2155 VGND.n1097 VGND.n969 585
R2156 VGND.n1096 VGND.n1095 585
R2157 VGND.n1094 VGND.n970 585
R2158 VGND.n1092 VGND.n1091 585
R2159 VGND.n1090 VGND.n972 585
R2160 VGND.n1089 VGND.n1088 585
R2161 VGND.n1087 VGND.n973 585
R2162 VGND.n1085 VGND.n1084 585
R2163 VGND.n1083 VGND.n975 585
R2164 VGND.n1082 VGND.n1081 585
R2165 VGND.n1080 VGND.n976 585
R2166 VGND.n1078 VGND.n1077 585
R2167 VGND.n1076 VGND.n978 585
R2168 VGND.n1075 VGND.n1074 585
R2169 VGND.n1073 VGND.n979 585
R2170 VGND.n1071 VGND.n1070 585
R2171 VGND.n1069 VGND.n981 585
R2172 VGND.n1068 VGND.n1067 585
R2173 VGND.n1066 VGND.n982 585
R2174 VGND.n1064 VGND.n1063 585
R2175 VGND.n1062 VGND.n984 585
R2176 VGND.n1061 VGND.n1060 585
R2177 VGND.n1059 VGND.n985 585
R2178 VGND.n1057 VGND.n1056 585
R2179 VGND.n1055 VGND.n987 585
R2180 VGND.n1054 VGND.n1053 585
R2181 VGND.n1052 VGND.n988 585
R2182 VGND.n1050 VGND.n1049 585
R2183 VGND.n1048 VGND.n990 585
R2184 VGND.n1047 VGND.n1046 585
R2185 VGND.n1045 VGND.n991 585
R2186 VGND.n1043 VGND.n1042 585
R2187 VGND.n1041 VGND.n993 585
R2188 VGND.n1040 VGND.n1039 585
R2189 VGND.n1038 VGND.n994 585
R2190 VGND.n1036 VGND.n1035 585
R2191 VGND.n1034 VGND.n996 585
R2192 VGND.n1033 VGND.n1032 585
R2193 VGND.n1031 VGND.n997 585
R2194 VGND.n1029 VGND.n1028 585
R2195 VGND.n1027 VGND.n999 585
R2196 VGND.n1026 VGND.n1025 585
R2197 VGND.n1024 VGND.n1000 585
R2198 VGND.n1022 VGND.n1021 585
R2199 VGND.n1020 VGND.n1002 585
R2200 VGND.n1019 VGND.n1018 585
R2201 VGND.n1017 VGND.n1003 585
R2202 VGND.n1015 VGND.n1014 585
R2203 VGND.n1013 VGND.n1005 585
R2204 VGND.n1012 VGND.n1011 585
R2205 VGND.n1010 VGND.n1007 585
R2206 VGND.n1006 VGND.n116 585
R2207 VGND.n1187 VGND.n1186 585
R2208 VGND.n1187 VGND.n117 585
R2209 VGND.n1188 VGND.n55 585
R2210 VGND.n1189 VGND.n1188 585
R2211 VGND.n1377 VGND.n87 585
R2212 VGND.n1190 VGND.n87 585
R2213 VGND.n1192 VGND.n1191 585
R2214 VGND.n1194 VGND.n1193 585
R2215 VGND.n1377 VGND.n85 585
R2216 VGND.n1195 VGND.n85 585
R2217 VGND.n1197 VGND.n1196 585
R2218 VGND.n1199 VGND.n1198 585
R2219 VGND.n1201 VGND.n1200 585
R2220 VGND.n1203 VGND.n1202 585
R2221 VGND.n1205 VGND.n1204 585
R2222 VGND.n1207 VGND.n1206 585
R2223 VGND.n1209 VGND.n1208 585
R2224 VGND.n1211 VGND.n1210 585
R2225 VGND.n1377 VGND.n91 585
R2226 VGND.n1212 VGND.n91 585
R2227 VGND.n1214 VGND.n1213 585
R2228 VGND.n1216 VGND.n1215 585
R2229 VGND.n1377 VGND.n82 585
R2230 VGND.n1217 VGND.n82 585
R2231 VGND.n1219 VGND.n1218 585
R2232 VGND.n1221 VGND.n1220 585
R2233 VGND.n1223 VGND.n1222 585
R2234 VGND.n1225 VGND.n1224 585
R2235 VGND.n1377 VGND.n94 585
R2236 VGND.n1226 VGND.n94 585
R2237 VGND.n1228 VGND.n1227 585
R2238 VGND.n1230 VGND.n1229 585
R2239 VGND.n1232 VGND.n1231 585
R2240 VGND.n1234 VGND.n1233 585
R2241 VGND.n1236 VGND.n1235 585
R2242 VGND.n1238 VGND.n1237 585
R2243 VGND.n1240 VGND.n1239 585
R2244 VGND.n1242 VGND.n1241 585
R2245 VGND.n1244 VGND.n1243 585
R2246 VGND.n1246 VGND.n1245 585
R2247 VGND.n1248 VGND.n1247 585
R2248 VGND.n1250 VGND.n1249 585
R2249 VGND.n1252 VGND.n1251 585
R2250 VGND.n1254 VGND.n1253 585
R2251 VGND.n1377 VGND.n76 585
R2252 VGND.n1255 VGND.n76 585
R2253 VGND.n1257 VGND.n1256 585
R2254 VGND.n1259 VGND.n1258 585
R2255 VGND.n1377 VGND.n98 585
R2256 VGND.n1260 VGND.n98 585
R2257 VGND.n1262 VGND.n1261 585
R2258 VGND.n1264 VGND.n1263 585
R2259 VGND.n1266 VGND.n1265 585
R2260 VGND.n1268 VGND.n1267 585
R2261 VGND.n1270 VGND.n1269 585
R2262 VGND.n1272 VGND.n1271 585
R2263 VGND.n1274 VGND.n1273 585
R2264 VGND.n1276 VGND.n1275 585
R2265 VGND.n1377 VGND.n71 585
R2266 VGND.n1277 VGND.n71 585
R2267 VGND.n1279 VGND.n1278 585
R2268 VGND.n1281 VGND.n1280 585
R2269 VGND.n1377 VGND.n100 585
R2270 VGND.n1282 VGND.n100 585
R2271 VGND.n1284 VGND.n1283 585
R2272 VGND.n1286 VGND.n1285 585
R2273 VGND.n1377 VGND.n69 585
R2274 VGND.n1287 VGND.n69 585
R2275 VGND.n1289 VGND.n1288 585
R2276 VGND.n1291 VGND.n1290 585
R2277 VGND.n1377 VGND.n102 585
R2278 VGND.n1292 VGND.n102 585
R2279 VGND.n1294 VGND.n1293 585
R2280 VGND.n1296 VGND.n1295 585
R2281 VGND.n1298 VGND.n1297 585
R2282 VGND.n1300 VGND.n1299 585
R2283 VGND.n1302 VGND.n1301 585
R2284 VGND.n1304 VGND.n1303 585
R2285 VGND.n1377 VGND.n65 585
R2286 VGND.n1305 VGND.n65 585
R2287 VGND.n1307 VGND.n1306 585
R2288 VGND.n1309 VGND.n1308 585
R2289 VGND.n1311 VGND.n1310 585
R2290 VGND.n1313 VGND.n1312 585
R2291 VGND.n1377 VGND.n105 585
R2292 VGND.n1314 VGND.n105 585
R2293 VGND.n1316 VGND.n1315 585
R2294 VGND.n1318 VGND.n1317 585
R2295 VGND.n1320 VGND.n1319 585
R2296 VGND.n1322 VGND.n1321 585
R2297 VGND.n1377 VGND.n62 585
R2298 VGND.n1323 VGND.n62 585
R2299 VGND.n1325 VGND.n1324 585
R2300 VGND.n1327 VGND.n1326 585
R2301 VGND.n1377 VGND.n107 585
R2302 VGND.n1328 VGND.n107 585
R2303 VGND.n1330 VGND.n1329 585
R2304 VGND.n1332 VGND.n1331 585
R2305 VGND.n1334 VGND.n1333 585
R2306 VGND.n1336 VGND.n1335 585
R2307 VGND.n1338 VGND.n1337 585
R2308 VGND.n1340 VGND.n1339 585
R2309 VGND.n1342 VGND.n1341 585
R2310 VGND.n1344 VGND.n1343 585
R2311 VGND.n1346 VGND.n1345 585
R2312 VGND.n1348 VGND.n1347 585
R2313 VGND.n1350 VGND.n1349 585
R2314 VGND.n1352 VGND.n1351 585
R2315 VGND.n1354 VGND.n1353 585
R2316 VGND.n1356 VGND.n1355 585
R2317 VGND.n1358 VGND.n1357 585
R2318 VGND.n1360 VGND.n1359 585
R2319 VGND.n1362 VGND.n1361 585
R2320 VGND.n1364 VGND.n1363 585
R2321 VGND.n1366 VGND.n1365 585
R2322 VGND.n1368 VGND.n1367 585
R2323 VGND.n1370 VGND.n1369 585
R2324 VGND.n1372 VGND.n1371 585
R2325 VGND.n1373 VGND.n113 585
R2326 VGND.n1375 VGND.n1374 585
R2327 VGND.n151 VGND.n118 585
R2328 VGND.n152 VGND.n151 585
R2329 VGND.n294 VGND.n293 585
R2330 VGND.n293 VGND.n292 585
R2331 VGND.n291 VGND.n158 585
R2332 VGND.n290 VGND.n289 585
R2333 VGND.n288 VGND.n159 585
R2334 VGND.n286 VGND.n285 585
R2335 VGND.n284 VGND.n161 585
R2336 VGND.n283 VGND.n282 585
R2337 VGND.n281 VGND.n162 585
R2338 VGND.n279 VGND.n278 585
R2339 VGND.n277 VGND.n164 585
R2340 VGND.n276 VGND.n275 585
R2341 VGND.n274 VGND.n165 585
R2342 VGND.n272 VGND.n271 585
R2343 VGND.n270 VGND.n167 585
R2344 VGND.n269 VGND.n268 585
R2345 VGND.n267 VGND.n168 585
R2346 VGND.n265 VGND.n264 585
R2347 VGND.n263 VGND.n170 585
R2348 VGND.n262 VGND.n261 585
R2349 VGND.n260 VGND.n171 585
R2350 VGND.n258 VGND.n257 585
R2351 VGND.n256 VGND.n173 585
R2352 VGND.n255 VGND.n254 585
R2353 VGND.n253 VGND.n174 585
R2354 VGND.n251 VGND.n250 585
R2355 VGND.n249 VGND.n176 585
R2356 VGND.n248 VGND.n247 585
R2357 VGND.n246 VGND.n177 585
R2358 VGND.n244 VGND.n243 585
R2359 VGND.n242 VGND.n179 585
R2360 VGND.n241 VGND.n240 585
R2361 VGND.n239 VGND.n180 585
R2362 VGND.n237 VGND.n236 585
R2363 VGND.n235 VGND.n182 585
R2364 VGND.n234 VGND.n233 585
R2365 VGND.n232 VGND.n183 585
R2366 VGND.n230 VGND.n229 585
R2367 VGND.n228 VGND.n185 585
R2368 VGND.n227 VGND.n226 585
R2369 VGND.n225 VGND.n186 585
R2370 VGND.n223 VGND.n222 585
R2371 VGND.n221 VGND.n188 585
R2372 VGND.n220 VGND.n219 585
R2373 VGND.n218 VGND.n189 585
R2374 VGND.n216 VGND.n215 585
R2375 VGND.n214 VGND.n191 585
R2376 VGND.n213 VGND.n212 585
R2377 VGND.n211 VGND.n192 585
R2378 VGND.n209 VGND.n208 585
R2379 VGND.n207 VGND.n194 585
R2380 VGND.n206 VGND.n205 585
R2381 VGND.n204 VGND.n195 585
R2382 VGND.n202 VGND.n201 585
R2383 VGND.n200 VGND.n198 585
R2384 VGND.n199 VGND.n154 585
R2385 VGND.n295 VGND.n294 585
R2386 VGND.n295 VGND.n156 585
R2387 VGND.n296 VGND.n118 585
R2388 VGND.n296 VGND.n153 585
R2389 VGND.n298 VGND.n297 585
R2390 VGND.n300 VGND.n299 585
R2391 VGND.n302 VGND.n301 585
R2392 VGND.n304 VGND.n303 585
R2393 VGND.n395 VGND.n131 585
R2394 VGND.n305 VGND.n131 585
R2395 VGND.n307 VGND.n306 585
R2396 VGND.n309 VGND.n308 585
R2397 VGND.n395 VGND.n135 585
R2398 VGND.n310 VGND.n135 585
R2399 VGND.n312 VGND.n311 585
R2400 VGND.n314 VGND.n313 585
R2401 VGND.n395 VGND.n129 585
R2402 VGND.n315 VGND.n129 585
R2403 VGND.n317 VGND.n316 585
R2404 VGND.n319 VGND.n318 585
R2405 VGND.n321 VGND.n320 585
R2406 VGND.n323 VGND.n322 585
R2407 VGND.n325 VGND.n324 585
R2408 VGND.n327 VGND.n326 585
R2409 VGND.n395 VGND.n138 585
R2410 VGND.n328 VGND.n138 585
R2411 VGND.n330 VGND.n329 585
R2412 VGND.n332 VGND.n331 585
R2413 VGND.n395 VGND.n126 585
R2414 VGND.n333 VGND.n126 585
R2415 VGND.n335 VGND.n334 585
R2416 VGND.n337 VGND.n336 585
R2417 VGND.n339 VGND.n338 585
R2418 VGND.n341 VGND.n340 585
R2419 VGND.n395 VGND.n141 585
R2420 VGND.n342 VGND.n141 585
R2421 VGND.n344 VGND.n343 585
R2422 VGND.n346 VGND.n345 585
R2423 VGND.n395 VGND.n124 585
R2424 VGND.n347 VGND.n124 585
R2425 VGND.n349 VGND.n348 585
R2426 VGND.n351 VGND.n350 585
R2427 VGND.n395 VGND.n143 585
R2428 VGND.n352 VGND.n143 585
R2429 VGND.n354 VGND.n353 585
R2430 VGND.n356 VGND.n355 585
R2431 VGND.n358 VGND.n357 585
R2432 VGND.n360 VGND.n359 585
R2433 VGND.n362 VGND.n361 585
R2434 VGND.n364 VGND.n363 585
R2435 VGND.n366 VGND.n365 585
R2436 VGND.n368 VGND.n367 585
R2437 VGND.n370 VGND.n369 585
R2438 VGND.n372 VGND.n371 585
R2439 VGND.n374 VGND.n373 585
R2440 VGND.n376 VGND.n375 585
R2441 VGND.n395 VGND.n119 585
R2442 VGND.n377 VGND.n119 585
R2443 VGND.n379 VGND.n378 585
R2444 VGND.n381 VGND.n380 585
R2445 VGND.n383 VGND.n382 585
R2446 VGND.n385 VGND.n384 585
R2447 VGND.n395 VGND.n148 585
R2448 VGND.n386 VGND.n148 585
R2449 VGND.n388 VGND.n387 585
R2450 VGND.n390 VGND.n389 585
R2451 VGND.n391 VGND.n150 585
R2452 VGND.n393 VGND.n392 585
R2453 VGND.n1877 VGND.n1876 585
R2454 VGND.n1876 VGND.n1875 585
R2455 VGND.n1378 VGND.n51 585
R2456 VGND.n1630 VGND.n51 585
R2457 VGND.n1628 VGND.n1627 585
R2458 VGND.n1629 VGND.n1628 585
R2459 VGND.n54 VGND.n53 585
R2460 VGND.n1625 VGND.n1624 585
R2461 VGND.n1623 VGND.n1428 585
R2462 VGND.n1622 VGND.n1621 585
R2463 VGND.n1620 VGND.n1619 585
R2464 VGND.n1618 VGND.n1617 585
R2465 VGND.n1616 VGND.n1615 585
R2466 VGND.n1614 VGND.n1613 585
R2467 VGND.n1612 VGND.n1611 585
R2468 VGND.n1610 VGND.n1609 585
R2469 VGND.n1608 VGND.n1607 585
R2470 VGND.n1606 VGND.n1605 585
R2471 VGND.n1604 VGND.n1603 585
R2472 VGND.n1602 VGND.n1601 585
R2473 VGND.n1600 VGND.n1599 585
R2474 VGND.n1598 VGND.n1597 585
R2475 VGND.n1596 VGND.n1595 585
R2476 VGND.n1594 VGND.n1593 585
R2477 VGND.n1592 VGND.n1591 585
R2478 VGND.n1590 VGND.n1589 585
R2479 VGND.n1588 VGND.n1587 585
R2480 VGND.n1586 VGND.n1585 585
R2481 VGND.n1584 VGND.n1583 585
R2482 VGND.n1582 VGND.n1581 585
R2483 VGND.n1580 VGND.n1579 585
R2484 VGND.n1578 VGND.n1577 585
R2485 VGND.n1576 VGND.n1575 585
R2486 VGND.n1574 VGND.n1573 585
R2487 VGND.n1572 VGND.n1571 585
R2488 VGND.n1570 VGND.n1569 585
R2489 VGND.n1568 VGND.n1567 585
R2490 VGND.n1566 VGND.n1565 585
R2491 VGND.n1564 VGND.n1563 585
R2492 VGND.n1562 VGND.n1561 585
R2493 VGND.n1560 VGND.n1559 585
R2494 VGND.n1558 VGND.n1557 585
R2495 VGND.n1556 VGND.n1555 585
R2496 VGND.n1554 VGND.n1553 585
R2497 VGND.n1552 VGND.n1551 585
R2498 VGND.n1550 VGND.n1549 585
R2499 VGND.n1548 VGND.n1547 585
R2500 VGND.n1546 VGND.n1545 585
R2501 VGND.n1544 VGND.n1543 585
R2502 VGND.n1542 VGND.n1541 585
R2503 VGND.n1540 VGND.n1539 585
R2504 VGND.n1538 VGND.n1537 585
R2505 VGND.n1536 VGND.n1535 585
R2506 VGND.n1534 VGND.n1533 585
R2507 VGND.n1532 VGND.n1531 585
R2508 VGND.n1530 VGND.n1529 585
R2509 VGND.n1528 VGND.n1527 585
R2510 VGND.n1526 VGND.n1525 585
R2511 VGND.n1524 VGND.n1523 585
R2512 VGND.n1522 VGND.n1521 585
R2513 VGND.n1520 VGND.n1519 585
R2514 VGND.n1518 VGND.n1517 585
R2515 VGND.n1516 VGND.n1515 585
R2516 VGND.n1514 VGND.n1513 585
R2517 VGND.n1512 VGND.n1511 585
R2518 VGND.n1510 VGND.n1509 585
R2519 VGND.n1508 VGND.n1507 585
R2520 VGND.n1506 VGND.n1505 585
R2521 VGND.n1504 VGND.n1503 585
R2522 VGND.n1502 VGND.n1501 585
R2523 VGND.n1500 VGND.n1499 585
R2524 VGND.n1498 VGND.n1497 585
R2525 VGND.n1496 VGND.n1495 585
R2526 VGND.n1494 VGND.n1493 585
R2527 VGND.n1492 VGND.n1491 585
R2528 VGND.n1490 VGND.n1489 585
R2529 VGND.n1488 VGND.n1487 585
R2530 VGND.n1486 VGND.n1485 585
R2531 VGND.n1484 VGND.n1483 585
R2532 VGND.n1482 VGND.n1481 585
R2533 VGND.n1480 VGND.n1479 585
R2534 VGND.n1478 VGND.n1477 585
R2535 VGND.n1476 VGND.n1475 585
R2536 VGND.n1474 VGND.n1473 585
R2537 VGND.n1472 VGND.n1471 585
R2538 VGND.n1470 VGND.n1469 585
R2539 VGND.n1468 VGND.n1467 585
R2540 VGND.n1466 VGND.n1465 585
R2541 VGND.n1464 VGND.n1463 585
R2542 VGND.n1462 VGND.n1461 585
R2543 VGND.n1460 VGND.n1459 585
R2544 VGND.n1458 VGND.n1457 585
R2545 VGND.n1456 VGND.n1455 585
R2546 VGND.n1454 VGND.n1453 585
R2547 VGND.n1452 VGND.n1451 585
R2548 VGND.n1450 VGND.n1449 585
R2549 VGND.n1448 VGND.n1447 585
R2550 VGND.n1446 VGND.n1445 585
R2551 VGND.n1444 VGND.n1443 585
R2552 VGND.n1442 VGND.n1441 585
R2553 VGND.n1440 VGND.n1439 585
R2554 VGND.n1438 VGND.n1437 585
R2555 VGND.n1436 VGND.n1435 585
R2556 VGND.n1434 VGND.n1433 585
R2557 VGND.n1432 VGND.n1431 585
R2558 VGND.n1430 VGND.n1429 585
R2559 VGND.n1378 VGND.n48 585
R2560 VGND.n48 VGND.n46 585
R2561 VGND.n1878 VGND.n1877 585
R2562 VGND.n1879 VGND.n1878 585
R2563 VGND.n49 VGND.n47 585
R2564 VGND.n1698 VGND.n1697 585
R2565 VGND.n1700 VGND.n1699 585
R2566 VGND.n1702 VGND.n1695 585
R2567 VGND.n1703 VGND.n50 585
R2568 VGND.n1703 VGND.n1693 585
R2569 VGND.n1705 VGND.n1704 585
R2570 VGND.n1706 VGND.n1692 585
R2571 VGND.n1708 VGND.n1707 585
R2572 VGND.n1710 VGND.n1691 585
R2573 VGND.n1711 VGND.n50 585
R2574 VGND.n1711 VGND.n1689 585
R2575 VGND.n1713 VGND.n1712 585
R2576 VGND.n1714 VGND.n1688 585
R2577 VGND.n1716 VGND.n1715 585
R2578 VGND.n1718 VGND.n1686 585
R2579 VGND.n1720 VGND.n1719 585
R2580 VGND.n1721 VGND.n1685 585
R2581 VGND.n1723 VGND.n1722 585
R2582 VGND.n1725 VGND.n1684 585
R2583 VGND.n1726 VGND.n50 585
R2584 VGND.n1726 VGND.n1683 585
R2585 VGND.n1729 VGND.n1728 585
R2586 VGND.n1730 VGND.n1682 585
R2587 VGND.n1732 VGND.n1731 585
R2588 VGND.n1734 VGND.n1681 585
R2589 VGND.n1735 VGND.n50 585
R2590 VGND.n1735 VGND.n1680 585
R2591 VGND.n1738 VGND.n1737 585
R2592 VGND.n1739 VGND.n1679 585
R2593 VGND.n1741 VGND.n1740 585
R2594 VGND.n1743 VGND.n1678 585
R2595 VGND.n1744 VGND.n50 585
R2596 VGND.n1744 VGND.n1677 585
R2597 VGND.n1747 VGND.n1746 585
R2598 VGND.n1748 VGND.n1676 585
R2599 VGND.n1750 VGND.n1749 585
R2600 VGND.n1752 VGND.n1674 585
R2601 VGND.n1754 VGND.n1753 585
R2602 VGND.n1755 VGND.n1673 585
R2603 VGND.n1757 VGND.n50 585
R2604 VGND.n1757 VGND.n1756 585
R2605 VGND.n1758 VGND.n1672 585
R2606 VGND.n1761 VGND.n1760 585
R2607 VGND.n1671 VGND.n50 585
R2608 VGND.n1762 VGND.n1671 585
R2609 VGND.n1764 VGND.n1763 585
R2610 VGND.n1766 VGND.n1670 585
R2611 VGND.n1767 VGND.n1669 585
R2612 VGND.n1770 VGND.n1769 585
R2613 VGND.n1668 VGND.n50 585
R2614 VGND.n1771 VGND.n1668 585
R2615 VGND.n1773 VGND.n1772 585
R2616 VGND.n1775 VGND.n1667 585
R2617 VGND.n1778 VGND.n1777 585
R2618 VGND.n1779 VGND.n1666 585
R2619 VGND.n1781 VGND.n1780 585
R2620 VGND.n1783 VGND.n1664 585
R2621 VGND.n1785 VGND.n1784 585
R2622 VGND.n1786 VGND.n1663 585
R2623 VGND.n1788 VGND.n1787 585
R2624 VGND.n1790 VGND.n1661 585
R2625 VGND.n1792 VGND.n1791 585
R2626 VGND.n1793 VGND.n1660 585
R2627 VGND.n1795 VGND.n1794 585
R2628 VGND.n1797 VGND.n1658 585
R2629 VGND.n1799 VGND.n1798 585
R2630 VGND.n1800 VGND.n1657 585
R2631 VGND.n1802 VGND.n1801 585
R2632 VGND.n1804 VGND.n1656 585
R2633 VGND.n1805 VGND.n50 585
R2634 VGND.n1805 VGND.n1654 585
R2635 VGND.n1807 VGND.n1806 585
R2636 VGND.n1808 VGND.n1653 585
R2637 VGND.n1810 VGND.n1809 585
R2638 VGND.n1812 VGND.n1651 585
R2639 VGND.n1814 VGND.n1813 585
R2640 VGND.n1815 VGND.n1650 585
R2641 VGND.n1817 VGND.n1816 585
R2642 VGND.n1819 VGND.n1649 585
R2643 VGND.n1820 VGND.n50 585
R2644 VGND.n1820 VGND.n1648 585
R2645 VGND.n1822 VGND.n1821 585
R2646 VGND.n1824 VGND.n1823 585
R2647 VGND.n1825 VGND.n1646 585
R2648 VGND.n1828 VGND.n1827 585
R2649 VGND.n1645 VGND.n50 585
R2650 VGND.n1829 VGND.n1645 585
R2651 VGND.n1831 VGND.n1830 585
R2652 VGND.n1833 VGND.n1643 585
R2653 VGND.n1835 VGND.n1834 585
R2654 VGND.n1836 VGND.n1642 585
R2655 VGND.n1838 VGND.n1837 585
R2656 VGND.n1840 VGND.n1640 585
R2657 VGND.n1842 VGND.n1841 585
R2658 VGND.n1843 VGND.n1639 585
R2659 VGND.n1845 VGND.n1844 585
R2660 VGND.n1847 VGND.n1638 585
R2661 VGND.n1850 VGND.n1849 585
R2662 VGND.n1851 VGND.n1637 585
R2663 VGND.n1853 VGND.n1852 585
R2664 VGND.n1855 VGND.n1635 585
R2665 VGND.n1857 VGND.n1856 585
R2666 VGND.n1858 VGND.n1634 585
R2667 VGND.n1860 VGND.n1859 585
R2668 VGND.n1862 VGND.n1633 585
R2669 VGND.n1865 VGND.n1864 585
R2670 VGND.n1866 VGND.n1632 585
R2671 VGND.n1868 VGND.n1867 585
R2672 VGND.n1870 VGND.n1631 585
R2673 VGND.n1873 VGND.n1872 585
R2674 VGND.n1874 VGND.n52 585
R2675 VGND.n725 VGND.n724 585
R2676 VGND.n726 VGND.n725 585
R2677 VGND.n681 VGND.n680 585
R2678 VGND.n727 VGND.n681 585
R2679 VGND.n730 VGND.n729 585
R2680 VGND.n729 VGND.n728 585
R2681 VGND.n731 VGND.n676 585
R2682 VGND.n676 VGND.n675 585
R2683 VGND.n733 VGND.n732 585
R2684 VGND.n734 VGND.n733 585
R2685 VGND.n674 VGND.n673 585
R2686 VGND.n735 VGND.n674 585
R2687 VGND.n738 VGND.n737 585
R2688 VGND.n737 VGND.n736 585
R2689 VGND.n667 VGND.n660 585
R2690 VGND.n669 VGND.n667 585
R2691 VGND.n766 VGND.n765 585
R2692 VGND.n765 VGND.n764 585
R2693 VGND.n763 VGND.n668 585
R2694 VGND.n762 VGND.n761 585
R2695 VGND.n760 VGND.n759 585
R2696 VGND.n758 VGND.n757 585
R2697 VGND.n756 VGND.n755 585
R2698 VGND.n754 VGND.n753 585
R2699 VGND.n752 VGND.n751 585
R2700 VGND.n750 VGND.n749 585
R2701 VGND.n748 VGND.n747 585
R2702 VGND.n746 VGND.n745 585
R2703 VGND.n744 VGND.n743 585
R2704 VGND.n742 VGND.n741 585
R2705 VGND.n740 VGND.n660 585
R2706 VGND.n740 VGND.n670 585
R2707 VGND.n739 VGND.n738 585
R2708 VGND.n739 VGND.n672 585
R2709 VGND.n673 VGND.n671 585
R2710 VGND.n692 VGND.n671 585
R2711 VGND.n732 VGND.n677 585
R2712 VGND.n693 VGND.n677 585
R2713 VGND.n731 VGND.n678 585
R2714 VGND.n695 VGND.n678 585
R2715 VGND.n730 VGND.n679 585
R2716 VGND.n696 VGND.n679 585
R2717 VGND.n697 VGND.n680 585
R2718 VGND.n698 VGND.n697 585
R2719 VGND.n724 VGND.n684 585
R2720 VGND.n699 VGND.n684 585
R2721 VGND.n701 VGND.n700 585
R2722 VGND.n703 VGND.n702 585
R2723 VGND.n705 VGND.n704 585
R2724 VGND.n707 VGND.n706 585
R2725 VGND.n709 VGND.n708 585
R2726 VGND.n711 VGND.n710 585
R2727 VGND.n713 VGND.n712 585
R2728 VGND.n715 VGND.n714 585
R2729 VGND.n723 VGND.n689 585
R2730 VGND.n716 VGND.n689 585
R2731 VGND.n718 VGND.n717 585
R2732 VGND.n719 VGND.n691 585
R2733 VGND.n721 VGND.n720 585
R2734 VGND.n683 VGND.n682 585
R2735 VGND.n799 VGND.n655 585
R2736 VGND.n655 VGND.n654 585
R2737 VGND.n801 VGND.n800 585
R2738 VGND.n802 VGND.n801 585
R2739 VGND.n603 VGND.n601 585
R2740 VGND.n803 VGND.n603 585
R2741 VGND.n806 VGND.n805 585
R2742 VGND.n805 VGND.n804 585
R2743 VGND.n649 VGND.n602 585
R2744 VGND.n653 VGND.n602 585
R2745 VGND.n651 VGND.n650 585
R2746 VGND.n652 VGND.n651 585
R2747 VGND.n606 VGND.n605 585
R2748 VGND.n605 VGND.n604 585
R2749 VGND.n643 VGND.n642 585
R2750 VGND.n642 VGND.n641 585
R2751 VGND.n611 VGND.n610 585
R2752 VGND.n640 VGND.n611 585
R2753 VGND.n639 VGND.n638 585
R2754 VGND.n636 VGND.n612 585
R2755 VGND.n635 VGND.n613 585
R2756 VGND.n633 VGND.n632 585
R2757 VGND.n631 VGND.n614 585
R2758 VGND.n630 VGND.n629 585
R2759 VGND.n628 VGND.n615 585
R2760 VGND.n626 VGND.n625 585
R2761 VGND.n624 VGND.n617 585
R2762 VGND.n623 VGND.n622 585
R2763 VGND.n621 VGND.n618 585
R2764 VGND.n609 VGND.n608 585
R2765 VGND.n644 VGND.n643 585
R2766 VGND.n645 VGND.n644 585
R2767 VGND.n607 VGND.n606 585
R2768 VGND.n646 VGND.n607 585
R2769 VGND.n650 VGND.n648 585
R2770 VGND.n648 VGND.n647 585
R2771 VGND.n649 VGND.n599 585
R2772 VGND.n599 VGND.n597 585
R2773 VGND.n807 VGND.n806 585
R2774 VGND.n808 VGND.n807 585
R2775 VGND.n601 VGND.n600 585
R2776 VGND.n600 VGND.n598 585
R2777 VGND.n800 VGND.n656 585
R2778 VGND.n773 VGND.n656 585
R2779 VGND.n799 VGND.n657 585
R2780 VGND.n774 VGND.n657 585
R2781 VGND.n776 VGND.n775 585
R2782 VGND.n778 VGND.n777 585
R2783 VGND.n798 VGND.n768 585
R2784 VGND.n779 VGND.n768 585
R2785 VGND.n781 VGND.n780 585
R2786 VGND.n783 VGND.n782 585
R2787 VGND.n785 VGND.n784 585
R2788 VGND.n787 VGND.n786 585
R2789 VGND.n798 VGND.n658 585
R2790 VGND.n788 VGND.n658 585
R2791 VGND.n790 VGND.n789 585
R2792 VGND.n792 VGND.n791 585
R2793 VGND.n798 VGND.n771 585
R2794 VGND.n793 VGND.n771 585
R2795 VGND.n794 VGND.n772 585
R2796 VGND.n796 VGND.n795 585
R2797 VGND.n2048 VGND.n2047 585
R2798 VGND.n2047 VGND.n2046 585
R2799 VGND.n2026 VGND.n2023 585
R2800 VGND.n2037 VGND.n2023 585
R2801 VGND.n2036 VGND.n2035 585
R2802 VGND.n2033 VGND.n2025 585
R2803 VGND.n2032 VGND.n2028 585
R2804 VGND.n2030 VGND.n2029 585
R2805 VGND.n2026 VGND.n16 585
R2806 VGND.n16 VGND.n14 585
R2807 VGND.n2049 VGND.n2048 585
R2808 VGND.n2050 VGND.n2049 585
R2809 VGND.n17 VGND.n15 585
R2810 VGND.n2039 VGND.n2038 585
R2811 VGND.n2044 VGND.n2043 585
R2812 VGND.n2045 VGND.n2024 585
R2813 VGND.n1886 VGND.n19 585
R2814 VGND.n1900 VGND.n1886 585
R2815 VGND.n1898 VGND.n18 585
R2816 VGND.n1899 VGND.n1898 585
R2817 VGND.n1897 VGND.n1887 585
R2818 VGND.n1895 VGND.n1894 585
R2819 VGND.n1893 VGND.n1889 585
R2820 VGND.n1892 VGND.n1891 585
R2821 VGND.n1883 VGND.n18 585
R2822 VGND.n1883 VGND.n1881 585
R2823 VGND.n1909 VGND.n19 585
R2824 VGND.n1910 VGND.n1909 585
R2825 VGND.n1908 VGND.n1882 585
R2826 VGND.n1901 VGND.n1884 585
R2827 VGND.n1902 VGND.n1885 585
R2828 VGND.n1904 VGND.n1903 585
R2829 VGND.n1917 VGND.n21 585
R2830 VGND.n1931 VGND.n1917 585
R2831 VGND.n1929 VGND.n20 585
R2832 VGND.n1930 VGND.n1929 585
R2833 VGND.n1928 VGND.n1918 585
R2834 VGND.n1926 VGND.n1925 585
R2835 VGND.n1924 VGND.n1920 585
R2836 VGND.n1923 VGND.n1922 585
R2837 VGND.n1914 VGND.n20 585
R2838 VGND.n1914 VGND.n1912 585
R2839 VGND.n1940 VGND.n21 585
R2840 VGND.n1941 VGND.n1940 585
R2841 VGND.n1939 VGND.n1913 585
R2842 VGND.n1932 VGND.n1915 585
R2843 VGND.n1933 VGND.n1916 585
R2844 VGND.n1935 VGND.n1934 585
R2845 VGND.n1948 VGND.n22 585
R2846 VGND.n1963 VGND.n1948 585
R2847 VGND.n1961 VGND.n1960 585
R2848 VGND.n1962 VGND.n1961 585
R2849 VGND.n1950 VGND.n1949 585
R2850 VGND.n1954 VGND.n1953 585
R2851 VGND.n1955 VGND.n1952 585
R2852 VGND.n1957 VGND.n1956 585
R2853 VGND.n1960 VGND.n1945 585
R2854 VGND.n1945 VGND.n1943 585
R2855 VGND.n1972 VGND.n22 585
R2856 VGND.n1973 VGND.n1972 585
R2857 VGND.n1971 VGND.n1944 585
R2858 VGND.n1964 VGND.n1946 585
R2859 VGND.n1965 VGND.n1947 585
R2860 VGND.n1967 VGND.n1966 585
R2861 VGND.n1981 VGND.n24 585
R2862 VGND.n1995 VGND.n1981 585
R2863 VGND.n1993 VGND.n23 585
R2864 VGND.n1994 VGND.n1993 585
R2865 VGND.n1992 VGND.n1982 585
R2866 VGND.n1990 VGND.n1989 585
R2867 VGND.n1988 VGND.n1984 585
R2868 VGND.n1987 VGND.n1986 585
R2869 VGND.n1978 VGND.n23 585
R2870 VGND.n1978 VGND.n1976 585
R2871 VGND.n2004 VGND.n24 585
R2872 VGND.n2005 VGND.n2004 585
R2873 VGND.n2003 VGND.n1977 585
R2874 VGND.n1996 VGND.n1979 585
R2875 VGND.n1997 VGND.n1980 585
R2876 VGND.n1999 VGND.n1998 585
R2877 VGND.n2020 VGND.n2019 585
R2878 VGND.n2019 VGND.n2018 585
R2879 VGND.n29 VGND.n25 585
R2880 VGND.n31 VGND.n29 585
R2881 VGND.n36 VGND.n35 585
R2882 VGND.n39 VGND.n38 585
R2883 VGND.n37 VGND.n34 585
R2884 VGND.n43 VGND.n33 585
R2885 VGND.n44 VGND.n25 585
R2886 VGND.n45 VGND.n44 585
R2887 VGND.n2020 VGND.n27 585
R2888 VGND.n2009 VGND.n27 585
R2889 VGND.n2011 VGND.n2010 585
R2890 VGND.n2013 VGND.n32 585
R2891 VGND.n2016 VGND.n2015 585
R2892 VGND.n2017 VGND.n30 585
R2893 VGND.n2041 VGND.n2022 584.375
R2894 VGND.n1627 VGND.n1377 422.473
R2895 VGND.n932 VGND.n931 408.555
R2896 VGND.n581 VGND.n475 394
R2897 VGND.n579 VGND.n473 394
R2898 VGND.n576 VGND.n473 394
R2899 VGND.n574 VGND.n573 394
R2900 VGND.n570 VGND.n569 394
R2901 VGND.n566 VGND.n565 394
R2902 VGND.n562 VGND.n468 394
R2903 VGND.n559 VGND.n468 394
R2904 VGND.n557 VGND.n556 394
R2905 VGND.n553 VGND.n552 394
R2906 VGND.n549 VGND.n548 394
R2907 VGND.n545 VGND.n463 394
R2908 VGND.n542 VGND.n463 394
R2909 VGND.n540 VGND.n539 394
R2910 VGND.n536 VGND.n535 394
R2911 VGND.n532 VGND.n531 394
R2912 VGND.n528 VGND.n527 394
R2913 VGND.n524 VGND.n523 394
R2914 VGND.n520 VGND.n519 394
R2915 VGND.n516 VGND.n515 394
R2916 VGND.n512 VGND.n511 394
R2917 VGND.n508 VGND.n507 394
R2918 VGND.n504 VGND.n503 394
R2919 VGND.n500 VGND.n499 394
R2920 VGND.n496 VGND.n495 394
R2921 VGND.n492 VGND.n449 394
R2922 VGND.n489 VGND.n449 394
R2923 VGND.n487 VGND.n486 394
R2924 VGND.n483 VGND.n446 394
R2925 VGND.n480 VGND.n446 394
R2926 VGND.n478 VGND.n477 394
R2927 VGND.n589 VGND.n443 394
R2928 VGND.n814 VGND.n396 394
R2929 VGND.n596 VGND.n396 394
R2930 VGND.n596 VGND.n595 394
R2931 VGND.n595 VGND.n439 394
R2932 VGND.n819 VGND.n818 394
R2933 VGND.n821 VGND.n416 394
R2934 VGND.n824 VGND.n416 394
R2935 VGND.n828 VGND.n827 394
R2936 VGND.n830 VGND.n422 394
R2937 VGND.n833 VGND.n422 394
R2938 VGND.n837 VGND.n836 394
R2939 VGND.n841 VGND.n840 394
R2940 VGND.n843 VGND.n412 394
R2941 VGND.n846 VGND.n412 394
R2942 VGND.n850 VGND.n849 394
R2943 VGND.n854 VGND.n853 394
R2944 VGND.n858 VGND.n857 394
R2945 VGND.n860 VGND.n425 394
R2946 VGND.n863 VGND.n425 394
R2947 VGND.n865 VGND.n408 394
R2948 VGND.n868 VGND.n408 394
R2949 VGND.n872 VGND.n871 394
R2950 VGND.n876 VGND.n875 394
R2951 VGND.n880 VGND.n879 394
R2952 VGND.n884 VGND.n883 394
R2953 VGND.n888 VGND.n887 394
R2954 VGND.n892 VGND.n891 394
R2955 VGND.n896 VGND.n895 394
R2956 VGND.n900 VGND.n899 394
R2957 VGND.n904 VGND.n903 394
R2958 VGND.n906 VGND.n433 394
R2959 VGND.n909 VGND.n433 394
R2960 VGND.n913 VGND.n912 394
R2961 VGND.n917 VGND.n916 394
R2962 VGND.n921 VGND.n436 394
R2963 VGND.n435 VGND.n402 394
R2964 VGND.n929 VGND.n399 394
R2965 VGND.n929 VGND.n398 394
R2966 VGND.n593 VGND.n398 394
R2967 VGND.n593 VGND.n441 394
R2968 VGND.n777 VGND.n768 394
R2969 VGND.n780 VGND.n768 394
R2970 VGND.n784 VGND.n783 394
R2971 VGND.n786 VGND.n658 394
R2972 VGND.n789 VGND.n658 394
R2973 VGND.n791 VGND.n771 394
R2974 VGND.n772 VGND.n771 394
R2975 VGND.n657 VGND.n656 394
R2976 VGND.n656 VGND.n600 394
R2977 VGND.n807 VGND.n600 394
R2978 VGND.n807 VGND.n599 394
R2979 VGND.n648 VGND.n599 394
R2980 VGND.n648 VGND.n607 394
R2981 VGND.n644 VGND.n607 394
R2982 VGND.n622 VGND.n621 394
R2983 VGND.n626 VGND.n617 394
R2984 VGND.n629 VGND.n628 394
R2985 VGND.n633 VGND.n614 394
R2986 VGND.n636 VGND.n635 394
R2987 VGND.n638 VGND.n611 394
R2988 VGND.n801 VGND.n655 394
R2989 VGND.n801 VGND.n603 394
R2990 VGND.n805 VGND.n603 394
R2991 VGND.n805 VGND.n602 394
R2992 VGND.n651 VGND.n602 394
R2993 VGND.n651 VGND.n605 394
R2994 VGND.n642 VGND.n605 394
R2995 VGND.n704 VGND.n703 394
R2996 VGND.n708 VGND.n707 394
R2997 VGND.n712 VGND.n711 394
R2998 VGND.n714 VGND.n689 394
R2999 VGND.n717 VGND.n689 394
R3000 VGND.n721 VGND.n691 394
R3001 VGND.n697 VGND.n684 394
R3002 VGND.n697 VGND.n679 394
R3003 VGND.n679 VGND.n678 394
R3004 VGND.n678 VGND.n677 394
R3005 VGND.n677 VGND.n671 394
R3006 VGND.n739 VGND.n671 394
R3007 VGND.n740 VGND.n739 394
R3008 VGND.n745 VGND.n744 394
R3009 VGND.n749 VGND.n748 394
R3010 VGND.n753 VGND.n752 394
R3011 VGND.n757 VGND.n756 394
R3012 VGND.n761 VGND.n760 394
R3013 VGND.n765 VGND.n668 394
R3014 VGND.n725 VGND.n681 394
R3015 VGND.n729 VGND.n681 394
R3016 VGND.n729 VGND.n676 394
R3017 VGND.n733 VGND.n676 394
R3018 VGND.n733 VGND.n674 394
R3019 VGND.n737 VGND.n674 394
R3020 VGND.n737 VGND.n667 394
R3021 VGND.n2043 VGND.n2039 394
R3022 VGND.n2049 VGND.n16 394
R3023 VGND.n2033 VGND.n2032 394
R3024 VGND.n2047 VGND.n2023 394
R3025 VGND.n1885 VGND.n1884 394
R3026 VGND.n1909 VGND.n1883 394
R3027 VGND.n1895 VGND.n1889 394
R3028 VGND.n1898 VGND.n1886 394
R3029 VGND.n1916 VGND.n1915 394
R3030 VGND.n1940 VGND.n1914 394
R3031 VGND.n1926 VGND.n1920 394
R3032 VGND.n1929 VGND.n1917 394
R3033 VGND.n1947 VGND.n1946 394
R3034 VGND.n1972 VGND.n1945 394
R3035 VGND.n1953 VGND.n1952 394
R3036 VGND.n1961 VGND.n1948 394
R3037 VGND.n1980 VGND.n1979 394
R3038 VGND.n2004 VGND.n1978 394
R3039 VGND.n1990 VGND.n1984 394
R3040 VGND.n1993 VGND.n1981 394
R3041 VGND.n2015 VGND.n2013 394
R3042 VGND.n44 VGND.n27 394
R3043 VGND.n39 VGND.n34 394
R3044 VGND.n2019 VGND.n29 394
R3045 VGND.n1700 VGND.n1697 394
R3046 VGND.n1703 VGND.n1702 394
R3047 VGND.n1704 VGND.n1703 394
R3048 VGND.n1708 VGND.n1692 394
R3049 VGND.n1711 VGND.n1710 394
R3050 VGND.n1712 VGND.n1711 394
R3051 VGND.n1716 VGND.n1688 394
R3052 VGND.n1719 VGND.n1718 394
R3053 VGND.n1723 VGND.n1685 394
R3054 VGND.n1726 VGND.n1725 394
R3055 VGND.n1728 VGND.n1726 394
R3056 VGND.n1732 VGND.n1682 394
R3057 VGND.n1735 VGND.n1734 394
R3058 VGND.n1737 VGND.n1735 394
R3059 VGND.n1741 VGND.n1679 394
R3060 VGND.n1744 VGND.n1743 394
R3061 VGND.n1746 VGND.n1744 394
R3062 VGND.n1750 VGND.n1676 394
R3063 VGND.n1753 VGND.n1752 394
R3064 VGND.n1757 VGND.n1673 394
R3065 VGND.n1758 VGND.n1757 394
R3066 VGND.n1760 VGND.n1671 394
R3067 VGND.n1764 VGND.n1671 394
R3068 VGND.n1767 VGND.n1766 394
R3069 VGND.n1769 VGND.n1668 394
R3070 VGND.n1773 VGND.n1668 394
R3071 VGND.n1777 VGND.n1775 394
R3072 VGND.n1781 VGND.n1666 394
R3073 VGND.n1784 VGND.n1783 394
R3074 VGND.n1788 VGND.n1663 394
R3075 VGND.n1791 VGND.n1790 394
R3076 VGND.n1795 VGND.n1660 394
R3077 VGND.n1798 VGND.n1797 394
R3078 VGND.n1802 VGND.n1657 394
R3079 VGND.n1805 VGND.n1804 394
R3080 VGND.n1806 VGND.n1805 394
R3081 VGND.n1810 VGND.n1653 394
R3082 VGND.n1813 VGND.n1812 394
R3083 VGND.n1817 VGND.n1650 394
R3084 VGND.n1820 VGND.n1819 394
R3085 VGND.n1821 VGND.n1820 394
R3086 VGND.n1825 VGND.n1824 394
R3087 VGND.n1827 VGND.n1645 394
R3088 VGND.n1831 VGND.n1645 394
R3089 VGND.n1834 VGND.n1833 394
R3090 VGND.n1838 VGND.n1642 394
R3091 VGND.n1841 VGND.n1840 394
R3092 VGND.n1845 VGND.n1639 394
R3093 VGND.n1849 VGND.n1847 394
R3094 VGND.n1853 VGND.n1637 394
R3095 VGND.n1856 VGND.n1855 394
R3096 VGND.n1860 VGND.n1634 394
R3097 VGND.n1864 VGND.n1862 394
R3098 VGND.n1868 VGND.n1632 394
R3099 VGND.n1872 VGND.n1870 394
R3100 VGND.n1878 VGND.n48 394
R3101 VGND.n1433 VGND.n1432 394
R3102 VGND.n1437 VGND.n1436 394
R3103 VGND.n1441 VGND.n1440 394
R3104 VGND.n1445 VGND.n1444 394
R3105 VGND.n1449 VGND.n1448 394
R3106 VGND.n1453 VGND.n1452 394
R3107 VGND.n1457 VGND.n1456 394
R3108 VGND.n1461 VGND.n1460 394
R3109 VGND.n1465 VGND.n1464 394
R3110 VGND.n1469 VGND.n1468 394
R3111 VGND.n1473 VGND.n1472 394
R3112 VGND.n1477 VGND.n1476 394
R3113 VGND.n1481 VGND.n1480 394
R3114 VGND.n1485 VGND.n1484 394
R3115 VGND.n1489 VGND.n1488 394
R3116 VGND.n1493 VGND.n1492 394
R3117 VGND.n1497 VGND.n1496 394
R3118 VGND.n1501 VGND.n1500 394
R3119 VGND.n1505 VGND.n1504 394
R3120 VGND.n1509 VGND.n1508 394
R3121 VGND.n1513 VGND.n1512 394
R3122 VGND.n1517 VGND.n1516 394
R3123 VGND.n1521 VGND.n1520 394
R3124 VGND.n1525 VGND.n1524 394
R3125 VGND.n1529 VGND.n1528 394
R3126 VGND.n1533 VGND.n1532 394
R3127 VGND.n1537 VGND.n1536 394
R3128 VGND.n1541 VGND.n1540 394
R3129 VGND.n1545 VGND.n1544 394
R3130 VGND.n1549 VGND.n1548 394
R3131 VGND.n1553 VGND.n1552 394
R3132 VGND.n1557 VGND.n1556 394
R3133 VGND.n1561 VGND.n1560 394
R3134 VGND.n1565 VGND.n1564 394
R3135 VGND.n1569 VGND.n1568 394
R3136 VGND.n1573 VGND.n1572 394
R3137 VGND.n1577 VGND.n1576 394
R3138 VGND.n1581 VGND.n1580 394
R3139 VGND.n1585 VGND.n1584 394
R3140 VGND.n1589 VGND.n1588 394
R3141 VGND.n1593 VGND.n1592 394
R3142 VGND.n1597 VGND.n1596 394
R3143 VGND.n1601 VGND.n1600 394
R3144 VGND.n1605 VGND.n1604 394
R3145 VGND.n1609 VGND.n1608 394
R3146 VGND.n1613 VGND.n1612 394
R3147 VGND.n1617 VGND.n1616 394
R3148 VGND.n1621 VGND.n1620 394
R3149 VGND.n1625 VGND.n1428 394
R3150 VGND.n1628 VGND.n54 394
R3151 VGND.n1876 VGND.n51 394
R3152 VGND.n301 VGND.n300 394
R3153 VGND.n303 VGND.n131 394
R3154 VGND.n306 VGND.n131 394
R3155 VGND.n308 VGND.n135 394
R3156 VGND.n311 VGND.n135 394
R3157 VGND.n313 VGND.n129 394
R3158 VGND.n316 VGND.n129 394
R3159 VGND.n320 VGND.n319 394
R3160 VGND.n324 VGND.n323 394
R3161 VGND.n326 VGND.n138 394
R3162 VGND.n329 VGND.n138 394
R3163 VGND.n331 VGND.n126 394
R3164 VGND.n334 VGND.n126 394
R3165 VGND.n338 VGND.n337 394
R3166 VGND.n340 VGND.n141 394
R3167 VGND.n343 VGND.n141 394
R3168 VGND.n345 VGND.n124 394
R3169 VGND.n348 VGND.n124 394
R3170 VGND.n350 VGND.n143 394
R3171 VGND.n353 VGND.n143 394
R3172 VGND.n357 VGND.n356 394
R3173 VGND.n361 VGND.n360 394
R3174 VGND.n365 VGND.n364 394
R3175 VGND.n369 VGND.n368 394
R3176 VGND.n373 VGND.n372 394
R3177 VGND.n375 VGND.n119 394
R3178 VGND.n378 VGND.n119 394
R3179 VGND.n382 VGND.n381 394
R3180 VGND.n384 VGND.n148 394
R3181 VGND.n387 VGND.n148 394
R3182 VGND.n389 VGND.n150 394
R3183 VGND.n296 VGND.n295 394
R3184 VGND.n202 VGND.n198 394
R3185 VGND.n205 VGND.n204 394
R3186 VGND.n209 VGND.n194 394
R3187 VGND.n212 VGND.n211 394
R3188 VGND.n216 VGND.n191 394
R3189 VGND.n219 VGND.n218 394
R3190 VGND.n223 VGND.n188 394
R3191 VGND.n226 VGND.n225 394
R3192 VGND.n230 VGND.n185 394
R3193 VGND.n233 VGND.n232 394
R3194 VGND.n237 VGND.n182 394
R3195 VGND.n240 VGND.n239 394
R3196 VGND.n244 VGND.n179 394
R3197 VGND.n247 VGND.n246 394
R3198 VGND.n251 VGND.n176 394
R3199 VGND.n254 VGND.n253 394
R3200 VGND.n258 VGND.n173 394
R3201 VGND.n261 VGND.n260 394
R3202 VGND.n265 VGND.n170 394
R3203 VGND.n268 VGND.n267 394
R3204 VGND.n272 VGND.n167 394
R3205 VGND.n275 VGND.n274 394
R3206 VGND.n279 VGND.n164 394
R3207 VGND.n282 VGND.n281 394
R3208 VGND.n286 VGND.n161 394
R3209 VGND.n289 VGND.n288 394
R3210 VGND.n293 VGND.n151 394
R3211 VGND.n1191 VGND.n87 394
R3212 VGND.n1193 VGND.n85 394
R3213 VGND.n1196 VGND.n85 394
R3214 VGND.n1200 VGND.n1199 394
R3215 VGND.n1204 VGND.n1203 394
R3216 VGND.n1208 VGND.n1207 394
R3217 VGND.n1210 VGND.n91 394
R3218 VGND.n1213 VGND.n91 394
R3219 VGND.n1215 VGND.n82 394
R3220 VGND.n1218 VGND.n82 394
R3221 VGND.n1222 VGND.n1221 394
R3222 VGND.n1224 VGND.n94 394
R3223 VGND.n1227 VGND.n94 394
R3224 VGND.n1231 VGND.n1230 394
R3225 VGND.n1235 VGND.n1234 394
R3226 VGND.n1239 VGND.n1238 394
R3227 VGND.n1243 VGND.n1242 394
R3228 VGND.n1247 VGND.n1246 394
R3229 VGND.n1251 VGND.n1250 394
R3230 VGND.n1253 VGND.n76 394
R3231 VGND.n1256 VGND.n76 394
R3232 VGND.n1258 VGND.n98 394
R3233 VGND.n1261 VGND.n98 394
R3234 VGND.n1265 VGND.n1264 394
R3235 VGND.n1269 VGND.n1268 394
R3236 VGND.n1273 VGND.n1272 394
R3237 VGND.n1275 VGND.n71 394
R3238 VGND.n1278 VGND.n71 394
R3239 VGND.n1280 VGND.n100 394
R3240 VGND.n1283 VGND.n100 394
R3241 VGND.n1285 VGND.n69 394
R3242 VGND.n1288 VGND.n69 394
R3243 VGND.n1290 VGND.n102 394
R3244 VGND.n1293 VGND.n102 394
R3245 VGND.n1297 VGND.n1296 394
R3246 VGND.n1301 VGND.n1300 394
R3247 VGND.n1303 VGND.n65 394
R3248 VGND.n1306 VGND.n65 394
R3249 VGND.n1310 VGND.n1309 394
R3250 VGND.n1312 VGND.n105 394
R3251 VGND.n1315 VGND.n105 394
R3252 VGND.n1319 VGND.n1318 394
R3253 VGND.n1321 VGND.n62 394
R3254 VGND.n1324 VGND.n62 394
R3255 VGND.n1326 VGND.n107 394
R3256 VGND.n1329 VGND.n107 394
R3257 VGND.n1333 VGND.n1332 394
R3258 VGND.n1337 VGND.n1336 394
R3259 VGND.n1341 VGND.n1340 394
R3260 VGND.n1345 VGND.n1344 394
R3261 VGND.n1349 VGND.n1348 394
R3262 VGND.n1353 VGND.n1352 394
R3263 VGND.n1357 VGND.n1356 394
R3264 VGND.n1361 VGND.n1360 394
R3265 VGND.n1365 VGND.n1364 394
R3266 VGND.n1369 VGND.n1368 394
R3267 VGND.n1371 VGND.n113 394
R3268 VGND.n1188 VGND.n1187 394
R3269 VGND.n1011 VGND.n1010 394
R3270 VGND.n1015 VGND.n1005 394
R3271 VGND.n1018 VGND.n1017 394
R3272 VGND.n1022 VGND.n1002 394
R3273 VGND.n1025 VGND.n1024 394
R3274 VGND.n1029 VGND.n999 394
R3275 VGND.n1032 VGND.n1031 394
R3276 VGND.n1036 VGND.n996 394
R3277 VGND.n1039 VGND.n1038 394
R3278 VGND.n1043 VGND.n993 394
R3279 VGND.n1046 VGND.n1045 394
R3280 VGND.n1050 VGND.n990 394
R3281 VGND.n1053 VGND.n1052 394
R3282 VGND.n1057 VGND.n987 394
R3283 VGND.n1060 VGND.n1059 394
R3284 VGND.n1064 VGND.n984 394
R3285 VGND.n1067 VGND.n1066 394
R3286 VGND.n1071 VGND.n981 394
R3287 VGND.n1074 VGND.n1073 394
R3288 VGND.n1078 VGND.n978 394
R3289 VGND.n1081 VGND.n1080 394
R3290 VGND.n1085 VGND.n975 394
R3291 VGND.n1088 VGND.n1087 394
R3292 VGND.n1092 VGND.n972 394
R3293 VGND.n1095 VGND.n1094 394
R3294 VGND.n1099 VGND.n969 394
R3295 VGND.n1102 VGND.n1101 394
R3296 VGND.n1106 VGND.n966 394
R3297 VGND.n1109 VGND.n1108 394
R3298 VGND.n1113 VGND.n963 394
R3299 VGND.n1116 VGND.n1115 394
R3300 VGND.n1120 VGND.n960 394
R3301 VGND.n1123 VGND.n1122 394
R3302 VGND.n1127 VGND.n957 394
R3303 VGND.n1130 VGND.n1129 394
R3304 VGND.n1134 VGND.n954 394
R3305 VGND.n1137 VGND.n1136 394
R3306 VGND.n1141 VGND.n951 394
R3307 VGND.n1144 VGND.n1143 394
R3308 VGND.n1148 VGND.n948 394
R3309 VGND.n1151 VGND.n1150 394
R3310 VGND.n1155 VGND.n945 394
R3311 VGND.n1158 VGND.n1157 394
R3312 VGND.n1162 VGND.n942 394
R3313 VGND.n1165 VGND.n1164 394
R3314 VGND.n1169 VGND.n939 394
R3315 VGND.n1172 VGND.n1171 394
R3316 VGND.n1176 VGND.n936 394
R3317 VGND.n1179 VGND.n1178 394
R3318 VGND.n1181 VGND.n933 394
R3319 VGND.n1185 VGND.n114 394
R3320 VGND.n923 VGND.n418 218.815
R3321 VGND.n923 VGND.n417 218.815
R3322 VGND.n923 VGND.n420 218.815
R3323 VGND.n923 VGND.n421 218.815
R3324 VGND.n923 VGND.n415 218.815
R3325 VGND.n923 VGND.n414 218.815
R3326 VGND.n923 VGND.n413 218.815
R3327 VGND.n923 VGND.n411 218.815
R3328 VGND.n923 VGND.n410 218.815
R3329 VGND.n923 VGND.n423 218.815
R3330 VGND.n923 VGND.n424 218.815
R3331 VGND.n923 VGND.n409 218.815
R3332 VGND.n923 VGND.n407 218.815
R3333 VGND.n923 VGND.n426 218.815
R3334 VGND.n923 VGND.n427 218.815
R3335 VGND.n923 VGND.n428 218.815
R3336 VGND.n923 VGND.n429 218.815
R3337 VGND.n923 VGND.n406 218.815
R3338 VGND.n923 VGND.n405 218.815
R3339 VGND.n923 VGND.n430 218.815
R3340 VGND.n923 VGND.n431 218.815
R3341 VGND.n923 VGND.n432 218.815
R3342 VGND.n923 VGND.n434 218.815
R3343 VGND.n923 VGND.n404 218.815
R3344 VGND.n923 VGND.n403 218.815
R3345 VGND.n923 VGND.n922 218.815
R3346 VGND.n924 VGND.n923 218.815
R3347 VGND.n588 VGND.n444 218.815
R3348 VGND.n588 VGND.n445 218.815
R3349 VGND.n588 VGND.n447 218.815
R3350 VGND.n588 VGND.n448 218.815
R3351 VGND.n588 VGND.n450 218.815
R3352 VGND.n588 VGND.n451 218.815
R3353 VGND.n588 VGND.n452 218.815
R3354 VGND.n588 VGND.n453 218.815
R3355 VGND.n588 VGND.n454 218.815
R3356 VGND.n588 VGND.n455 218.815
R3357 VGND.n588 VGND.n456 218.815
R3358 VGND.n588 VGND.n457 218.815
R3359 VGND.n588 VGND.n458 218.815
R3360 VGND.n588 VGND.n459 218.815
R3361 VGND.n588 VGND.n460 218.815
R3362 VGND.n588 VGND.n461 218.815
R3363 VGND.n588 VGND.n462 218.815
R3364 VGND.n588 VGND.n464 218.815
R3365 VGND.n588 VGND.n465 218.815
R3366 VGND.n588 VGND.n466 218.815
R3367 VGND.n588 VGND.n467 218.815
R3368 VGND.n588 VGND.n469 218.815
R3369 VGND.n588 VGND.n470 218.815
R3370 VGND.n588 VGND.n471 218.815
R3371 VGND.n588 VGND.n472 218.815
R3372 VGND.n588 VGND.n474 218.815
R3373 VGND.n588 VGND.n587 218.815
R3374 VGND.n1180 VGND.n932 218.815
R3375 VGND.n1177 VGND.n932 218.815
R3376 VGND.n938 VGND.n932 218.815
R3377 VGND.n1170 VGND.n932 218.815
R3378 VGND.n941 VGND.n932 218.815
R3379 VGND.n1163 VGND.n932 218.815
R3380 VGND.n944 VGND.n932 218.815
R3381 VGND.n1156 VGND.n932 218.815
R3382 VGND.n947 VGND.n932 218.815
R3383 VGND.n1149 VGND.n932 218.815
R3384 VGND.n950 VGND.n932 218.815
R3385 VGND.n1142 VGND.n932 218.815
R3386 VGND.n953 VGND.n932 218.815
R3387 VGND.n1135 VGND.n932 218.815
R3388 VGND.n956 VGND.n932 218.815
R3389 VGND.n1128 VGND.n932 218.815
R3390 VGND.n959 VGND.n932 218.815
R3391 VGND.n1121 VGND.n932 218.815
R3392 VGND.n962 VGND.n932 218.815
R3393 VGND.n1114 VGND.n932 218.815
R3394 VGND.n965 VGND.n932 218.815
R3395 VGND.n1107 VGND.n932 218.815
R3396 VGND.n968 VGND.n932 218.815
R3397 VGND.n1100 VGND.n932 218.815
R3398 VGND.n971 VGND.n932 218.815
R3399 VGND.n1093 VGND.n932 218.815
R3400 VGND.n974 VGND.n932 218.815
R3401 VGND.n1086 VGND.n932 218.815
R3402 VGND.n977 VGND.n932 218.815
R3403 VGND.n1079 VGND.n932 218.815
R3404 VGND.n980 VGND.n932 218.815
R3405 VGND.n1072 VGND.n932 218.815
R3406 VGND.n983 VGND.n932 218.815
R3407 VGND.n1065 VGND.n932 218.815
R3408 VGND.n986 VGND.n932 218.815
R3409 VGND.n1058 VGND.n932 218.815
R3410 VGND.n989 VGND.n932 218.815
R3411 VGND.n1051 VGND.n932 218.815
R3412 VGND.n992 VGND.n932 218.815
R3413 VGND.n1044 VGND.n932 218.815
R3414 VGND.n995 VGND.n932 218.815
R3415 VGND.n1037 VGND.n932 218.815
R3416 VGND.n998 VGND.n932 218.815
R3417 VGND.n1030 VGND.n932 218.815
R3418 VGND.n1001 VGND.n932 218.815
R3419 VGND.n1023 VGND.n932 218.815
R3420 VGND.n1004 VGND.n932 218.815
R3421 VGND.n1016 VGND.n932 218.815
R3422 VGND.n1008 VGND.n932 218.815
R3423 VGND.n1009 VGND.n932 218.815
R3424 VGND.n1377 VGND.n86 218.815
R3425 VGND.n1377 VGND.n88 218.815
R3426 VGND.n1377 VGND.n89 218.815
R3427 VGND.n1377 VGND.n84 218.815
R3428 VGND.n1377 VGND.n90 218.815
R3429 VGND.n1377 VGND.n83 218.815
R3430 VGND.n1377 VGND.n92 218.815
R3431 VGND.n1377 VGND.n93 218.815
R3432 VGND.n1377 VGND.n81 218.815
R3433 VGND.n1377 VGND.n95 218.815
R3434 VGND.n1377 VGND.n80 218.815
R3435 VGND.n1377 VGND.n96 218.815
R3436 VGND.n1377 VGND.n79 218.815
R3437 VGND.n1377 VGND.n78 218.815
R3438 VGND.n1377 VGND.n77 218.815
R3439 VGND.n1377 VGND.n97 218.815
R3440 VGND.n1377 VGND.n75 218.815
R3441 VGND.n1377 VGND.n74 218.815
R3442 VGND.n1377 VGND.n73 218.815
R3443 VGND.n1377 VGND.n72 218.815
R3444 VGND.n1377 VGND.n99 218.815
R3445 VGND.n1377 VGND.n70 218.815
R3446 VGND.n1377 VGND.n101 218.815
R3447 VGND.n1377 VGND.n68 218.815
R3448 VGND.n1377 VGND.n67 218.815
R3449 VGND.n1377 VGND.n66 218.815
R3450 VGND.n1377 VGND.n103 218.815
R3451 VGND.n1377 VGND.n104 218.815
R3452 VGND.n1377 VGND.n64 218.815
R3453 VGND.n1377 VGND.n63 218.815
R3454 VGND.n1377 VGND.n106 218.815
R3455 VGND.n1377 VGND.n108 218.815
R3456 VGND.n1377 VGND.n109 218.815
R3457 VGND.n1377 VGND.n110 218.815
R3458 VGND.n1377 VGND.n61 218.815
R3459 VGND.n1377 VGND.n60 218.815
R3460 VGND.n1377 VGND.n59 218.815
R3461 VGND.n1377 VGND.n111 218.815
R3462 VGND.n1377 VGND.n58 218.815
R3463 VGND.n1377 VGND.n57 218.815
R3464 VGND.n1377 VGND.n112 218.815
R3465 VGND.n1377 VGND.n56 218.815
R3466 VGND.n1377 VGND.n1376 218.815
R3467 VGND.n160 VGND.n157 218.815
R3468 VGND.n287 VGND.n157 218.815
R3469 VGND.n163 VGND.n157 218.815
R3470 VGND.n280 VGND.n157 218.815
R3471 VGND.n166 VGND.n157 218.815
R3472 VGND.n273 VGND.n157 218.815
R3473 VGND.n169 VGND.n157 218.815
R3474 VGND.n266 VGND.n157 218.815
R3475 VGND.n172 VGND.n157 218.815
R3476 VGND.n259 VGND.n157 218.815
R3477 VGND.n175 VGND.n157 218.815
R3478 VGND.n252 VGND.n157 218.815
R3479 VGND.n178 VGND.n157 218.815
R3480 VGND.n245 VGND.n157 218.815
R3481 VGND.n181 VGND.n157 218.815
R3482 VGND.n238 VGND.n157 218.815
R3483 VGND.n184 VGND.n157 218.815
R3484 VGND.n231 VGND.n157 218.815
R3485 VGND.n187 VGND.n157 218.815
R3486 VGND.n224 VGND.n157 218.815
R3487 VGND.n190 VGND.n157 218.815
R3488 VGND.n217 VGND.n157 218.815
R3489 VGND.n193 VGND.n157 218.815
R3490 VGND.n210 VGND.n157 218.815
R3491 VGND.n196 VGND.n157 218.815
R3492 VGND.n203 VGND.n157 218.815
R3493 VGND.n197 VGND.n157 218.815
R3494 VGND.n395 VGND.n133 218.815
R3495 VGND.n395 VGND.n132 218.815
R3496 VGND.n395 VGND.n134 218.815
R3497 VGND.n395 VGND.n130 218.815
R3498 VGND.n395 VGND.n128 218.815
R3499 VGND.n395 VGND.n136 218.815
R3500 VGND.n395 VGND.n137 218.815
R3501 VGND.n395 VGND.n127 218.815
R3502 VGND.n395 VGND.n139 218.815
R3503 VGND.n395 VGND.n140 218.815
R3504 VGND.n395 VGND.n125 218.815
R3505 VGND.n395 VGND.n142 218.815
R3506 VGND.n395 VGND.n123 218.815
R3507 VGND.n395 VGND.n122 218.815
R3508 VGND.n395 VGND.n144 218.815
R3509 VGND.n395 VGND.n121 218.815
R3510 VGND.n395 VGND.n145 218.815
R3511 VGND.n395 VGND.n120 218.815
R3512 VGND.n395 VGND.n146 218.815
R3513 VGND.n395 VGND.n147 218.815
R3514 VGND.n395 VGND.n149 218.815
R3515 VGND.n395 VGND.n394 218.815
R3516 VGND.n1627 VGND.n1626 218.815
R3517 VGND.n1627 VGND.n1427 218.815
R3518 VGND.n1627 VGND.n1426 218.815
R3519 VGND.n1627 VGND.n1425 218.815
R3520 VGND.n1627 VGND.n1424 218.815
R3521 VGND.n1627 VGND.n1423 218.815
R3522 VGND.n1627 VGND.n1422 218.815
R3523 VGND.n1627 VGND.n1421 218.815
R3524 VGND.n1627 VGND.n1420 218.815
R3525 VGND.n1627 VGND.n1419 218.815
R3526 VGND.n1627 VGND.n1418 218.815
R3527 VGND.n1627 VGND.n1417 218.815
R3528 VGND.n1627 VGND.n1416 218.815
R3529 VGND.n1627 VGND.n1415 218.815
R3530 VGND.n1627 VGND.n1414 218.815
R3531 VGND.n1627 VGND.n1413 218.815
R3532 VGND.n1627 VGND.n1412 218.815
R3533 VGND.n1627 VGND.n1411 218.815
R3534 VGND.n1627 VGND.n1410 218.815
R3535 VGND.n1627 VGND.n1409 218.815
R3536 VGND.n1627 VGND.n1408 218.815
R3537 VGND.n1627 VGND.n1407 218.815
R3538 VGND.n1627 VGND.n1406 218.815
R3539 VGND.n1627 VGND.n1405 218.815
R3540 VGND.n1627 VGND.n1404 218.815
R3541 VGND.n1627 VGND.n1403 218.815
R3542 VGND.n1627 VGND.n1402 218.815
R3543 VGND.n1627 VGND.n1401 218.815
R3544 VGND.n1627 VGND.n1400 218.815
R3545 VGND.n1627 VGND.n1399 218.815
R3546 VGND.n1627 VGND.n1398 218.815
R3547 VGND.n1627 VGND.n1397 218.815
R3548 VGND.n1627 VGND.n1396 218.815
R3549 VGND.n1627 VGND.n1395 218.815
R3550 VGND.n1627 VGND.n1394 218.815
R3551 VGND.n1627 VGND.n1393 218.815
R3552 VGND.n1627 VGND.n1392 218.815
R3553 VGND.n1627 VGND.n1391 218.815
R3554 VGND.n1627 VGND.n1390 218.815
R3555 VGND.n1627 VGND.n1389 218.815
R3556 VGND.n1627 VGND.n1388 218.815
R3557 VGND.n1627 VGND.n1387 218.815
R3558 VGND.n1627 VGND.n1386 218.815
R3559 VGND.n1627 VGND.n1385 218.815
R3560 VGND.n1627 VGND.n1384 218.815
R3561 VGND.n1627 VGND.n1383 218.815
R3562 VGND.n1627 VGND.n1382 218.815
R3563 VGND.n1627 VGND.n1381 218.815
R3564 VGND.n1627 VGND.n1380 218.815
R3565 VGND.n1627 VGND.n1379 218.815
R3566 VGND.n1696 VGND.n50 218.815
R3567 VGND.n1701 VGND.n50 218.815
R3568 VGND.n1694 VGND.n50 218.815
R3569 VGND.n1709 VGND.n50 218.815
R3570 VGND.n1690 VGND.n50 218.815
R3571 VGND.n1717 VGND.n50 218.815
R3572 VGND.n1687 VGND.n50 218.815
R3573 VGND.n1724 VGND.n50 218.815
R3574 VGND.n1727 VGND.n50 218.815
R3575 VGND.n1733 VGND.n50 218.815
R3576 VGND.n1736 VGND.n50 218.815
R3577 VGND.n1742 VGND.n50 218.815
R3578 VGND.n1745 VGND.n50 218.815
R3579 VGND.n1751 VGND.n50 218.815
R3580 VGND.n1675 VGND.n50 218.815
R3581 VGND.n1759 VGND.n50 218.815
R3582 VGND.n1765 VGND.n50 218.815
R3583 VGND.n1768 VGND.n50 218.815
R3584 VGND.n1774 VGND.n50 218.815
R3585 VGND.n1776 VGND.n50 218.815
R3586 VGND.n1782 VGND.n50 218.815
R3587 VGND.n1665 VGND.n50 218.815
R3588 VGND.n1789 VGND.n50 218.815
R3589 VGND.n1662 VGND.n50 218.815
R3590 VGND.n1796 VGND.n50 218.815
R3591 VGND.n1659 VGND.n50 218.815
R3592 VGND.n1803 VGND.n50 218.815
R3593 VGND.n1655 VGND.n50 218.815
R3594 VGND.n1811 VGND.n50 218.815
R3595 VGND.n1652 VGND.n50 218.815
R3596 VGND.n1818 VGND.n50 218.815
R3597 VGND.n1647 VGND.n50 218.815
R3598 VGND.n1826 VGND.n50 218.815
R3599 VGND.n1832 VGND.n50 218.815
R3600 VGND.n1644 VGND.n50 218.815
R3601 VGND.n1839 VGND.n50 218.815
R3602 VGND.n1641 VGND.n50 218.815
R3603 VGND.n1846 VGND.n50 218.815
R3604 VGND.n1848 VGND.n50 218.815
R3605 VGND.n1854 VGND.n50 218.815
R3606 VGND.n1636 VGND.n50 218.815
R3607 VGND.n1861 VGND.n50 218.815
R3608 VGND.n1863 VGND.n50 218.815
R3609 VGND.n1869 VGND.n50 218.815
R3610 VGND.n1871 VGND.n50 218.815
R3611 VGND.n766 VGND.n666 218.815
R3612 VGND.n766 VGND.n665 218.815
R3613 VGND.n766 VGND.n664 218.815
R3614 VGND.n766 VGND.n663 218.815
R3615 VGND.n766 VGND.n662 218.815
R3616 VGND.n766 VGND.n661 218.815
R3617 VGND.n723 VGND.n686 218.815
R3618 VGND.n723 VGND.n687 218.815
R3619 VGND.n723 VGND.n685 218.815
R3620 VGND.n723 VGND.n688 218.815
R3621 VGND.n723 VGND.n690 218.815
R3622 VGND.n723 VGND.n722 218.815
R3623 VGND.n637 VGND.n610 218.815
R3624 VGND.n634 VGND.n610 218.815
R3625 VGND.n616 VGND.n610 218.815
R3626 VGND.n627 VGND.n610 218.815
R3627 VGND.n619 VGND.n610 218.815
R3628 VGND.n620 VGND.n610 218.815
R3629 VGND.n798 VGND.n767 218.815
R3630 VGND.n798 VGND.n769 218.815
R3631 VGND.n798 VGND.n659 218.815
R3632 VGND.n798 VGND.n770 218.815
R3633 VGND.n798 VGND.n797 218.815
R3634 VGND.n2034 VGND.n2027 218.815
R3635 VGND.n2031 VGND.n2027 218.815
R3636 VGND.n2041 VGND.n2040 218.815
R3637 VGND.n2042 VGND.n2041 218.815
R3638 VGND.n1896 VGND.n1888 218.815
R3639 VGND.n1890 VGND.n1888 218.815
R3640 VGND.n1907 VGND.n1906 218.815
R3641 VGND.n1906 VGND.n1905 218.815
R3642 VGND.n1927 VGND.n1919 218.815
R3643 VGND.n1921 VGND.n1919 218.815
R3644 VGND.n1938 VGND.n1937 218.815
R3645 VGND.n1937 VGND.n1936 218.815
R3646 VGND.n1959 VGND.n1951 218.815
R3647 VGND.n1959 VGND.n1958 218.815
R3648 VGND.n1970 VGND.n1969 218.815
R3649 VGND.n1969 VGND.n1968 218.815
R3650 VGND.n1991 VGND.n1983 218.815
R3651 VGND.n1985 VGND.n1983 218.815
R3652 VGND.n2002 VGND.n2001 218.815
R3653 VGND.n2001 VGND.n2000 218.815
R3654 VGND.n41 VGND.n40 218.815
R3655 VGND.n42 VGND.n41 218.815
R3656 VGND.n2012 VGND.n28 218.815
R3657 VGND.n2014 VGND.n28 218.815
R3658 VGND.n2048 VGND.t48 194.792
R3659 VGND.n2026 VGND.t48 194.792
R3660 VGND.t52 VGND.n19 194.792
R3661 VGND.t52 VGND.n18 194.792
R3662 VGND.t45 VGND.n21 194.792
R3663 VGND.t45 VGND.n20 194.792
R3664 VGND.n1960 VGND.t50 194.792
R3665 VGND.t54 VGND.n24 194.792
R3666 VGND.t54 VGND.n23 194.792
R3667 VGND.t47 VGND.n2020 194.792
R3668 VGND.t47 VGND.n25 194.792
R3669 VGND.n931 VGND.n395 184.274
R3670 VGND.n818 VGND.n418 147.374
R3671 VGND.n821 VGND.n417 147.374
R3672 VGND.n827 VGND.n420 147.374
R3673 VGND.n830 VGND.n421 147.374
R3674 VGND.n836 VGND.n415 147.374
R3675 VGND.n840 VGND.n414 147.374
R3676 VGND.n843 VGND.n413 147.374
R3677 VGND.n846 VGND.n411 147.374
R3678 VGND.n850 VGND.n410 147.374
R3679 VGND.n857 VGND.n423 147.374
R3680 VGND.n860 VGND.n424 147.374
R3681 VGND.n865 VGND.n409 147.374
R3682 VGND.n868 VGND.n407 147.374
R3683 VGND.n875 VGND.n426 147.374
R3684 VGND.n879 VGND.n427 147.374
R3685 VGND.n883 VGND.n428 147.374
R3686 VGND.n887 VGND.n429 147.374
R3687 VGND.n888 VGND.n406 147.374
R3688 VGND.n892 VGND.n405 147.374
R3689 VGND.n899 VGND.n430 147.374
R3690 VGND.n903 VGND.n431 147.374
R3691 VGND.n906 VGND.n432 147.374
R3692 VGND.n909 VGND.n434 147.374
R3693 VGND.n916 VGND.n404 147.374
R3694 VGND.n436 VGND.n403 147.374
R3695 VGND.n922 VGND.n921 147.374
R3696 VGND.n924 VGND.n402 147.374
R3697 VGND.n444 VGND.n443 147.374
R3698 VGND.n478 VGND.n445 147.374
R3699 VGND.n483 VGND.n447 147.374
R3700 VGND.n489 VGND.n448 147.374
R3701 VGND.n492 VGND.n450 147.374
R3702 VGND.n496 VGND.n451 147.374
R3703 VGND.n500 VGND.n452 147.374
R3704 VGND.n504 VGND.n453 147.374
R3705 VGND.n511 VGND.n454 147.374
R3706 VGND.n512 VGND.n455 147.374
R3707 VGND.n516 VGND.n456 147.374
R3708 VGND.n520 VGND.n457 147.374
R3709 VGND.n527 VGND.n458 147.374
R3710 VGND.n531 VGND.n459 147.374
R3711 VGND.n532 VGND.n460 147.374
R3712 VGND.n536 VGND.n461 147.374
R3713 VGND.n540 VGND.n462 147.374
R3714 VGND.n545 VGND.n464 147.374
R3715 VGND.n549 VGND.n465 147.374
R3716 VGND.n553 VGND.n466 147.374
R3717 VGND.n557 VGND.n467 147.374
R3718 VGND.n562 VGND.n469 147.374
R3719 VGND.n566 VGND.n470 147.374
R3720 VGND.n573 VGND.n471 147.374
R3721 VGND.n574 VGND.n472 147.374
R3722 VGND.n579 VGND.n474 147.374
R3723 VGND.n587 VGND.n586 147.374
R3724 VGND.n587 VGND.n475 147.374
R3725 VGND.n581 VGND.n474 147.374
R3726 VGND.n576 VGND.n472 147.374
R3727 VGND.n570 VGND.n471 147.374
R3728 VGND.n569 VGND.n470 147.374
R3729 VGND.n565 VGND.n469 147.374
R3730 VGND.n559 VGND.n467 147.374
R3731 VGND.n556 VGND.n466 147.374
R3732 VGND.n552 VGND.n465 147.374
R3733 VGND.n548 VGND.n464 147.374
R3734 VGND.n542 VGND.n462 147.374
R3735 VGND.n539 VGND.n461 147.374
R3736 VGND.n535 VGND.n460 147.374
R3737 VGND.n528 VGND.n459 147.374
R3738 VGND.n524 VGND.n458 147.374
R3739 VGND.n523 VGND.n457 147.374
R3740 VGND.n519 VGND.n456 147.374
R3741 VGND.n515 VGND.n455 147.374
R3742 VGND.n508 VGND.n454 147.374
R3743 VGND.n507 VGND.n453 147.374
R3744 VGND.n503 VGND.n452 147.374
R3745 VGND.n499 VGND.n451 147.374
R3746 VGND.n495 VGND.n450 147.374
R3747 VGND.n487 VGND.n448 147.374
R3748 VGND.n486 VGND.n447 147.374
R3749 VGND.n480 VGND.n445 147.374
R3750 VGND.n477 VGND.n444 147.374
R3751 VGND.n815 VGND.n418 147.374
R3752 VGND.n819 VGND.n417 147.374
R3753 VGND.n824 VGND.n420 147.374
R3754 VGND.n828 VGND.n421 147.374
R3755 VGND.n833 VGND.n415 147.374
R3756 VGND.n837 VGND.n414 147.374
R3757 VGND.n841 VGND.n413 147.374
R3758 VGND.n849 VGND.n411 147.374
R3759 VGND.n853 VGND.n410 147.374
R3760 VGND.n854 VGND.n423 147.374
R3761 VGND.n858 VGND.n424 147.374
R3762 VGND.n863 VGND.n409 147.374
R3763 VGND.n871 VGND.n407 147.374
R3764 VGND.n872 VGND.n426 147.374
R3765 VGND.n876 VGND.n427 147.374
R3766 VGND.n880 VGND.n428 147.374
R3767 VGND.n884 VGND.n429 147.374
R3768 VGND.n891 VGND.n406 147.374
R3769 VGND.n895 VGND.n405 147.374
R3770 VGND.n896 VGND.n430 147.374
R3771 VGND.n900 VGND.n431 147.374
R3772 VGND.n904 VGND.n432 147.374
R3773 VGND.n912 VGND.n434 147.374
R3774 VGND.n913 VGND.n404 147.374
R3775 VGND.n917 VGND.n403 147.374
R3776 VGND.n922 VGND.n435 147.374
R3777 VGND.n925 VGND.n924 147.374
R3778 VGND.n1181 VGND.n1180 147.374
R3779 VGND.n1178 VGND.n1177 147.374
R3780 VGND.n938 VGND.n936 147.374
R3781 VGND.n1171 VGND.n1170 147.374
R3782 VGND.n941 VGND.n939 147.374
R3783 VGND.n1164 VGND.n1163 147.374
R3784 VGND.n944 VGND.n942 147.374
R3785 VGND.n1157 VGND.n1156 147.374
R3786 VGND.n947 VGND.n945 147.374
R3787 VGND.n1150 VGND.n1149 147.374
R3788 VGND.n950 VGND.n948 147.374
R3789 VGND.n1143 VGND.n1142 147.374
R3790 VGND.n953 VGND.n951 147.374
R3791 VGND.n1136 VGND.n1135 147.374
R3792 VGND.n956 VGND.n954 147.374
R3793 VGND.n1129 VGND.n1128 147.374
R3794 VGND.n959 VGND.n957 147.374
R3795 VGND.n1122 VGND.n1121 147.374
R3796 VGND.n962 VGND.n960 147.374
R3797 VGND.n1115 VGND.n1114 147.374
R3798 VGND.n965 VGND.n963 147.374
R3799 VGND.n1108 VGND.n1107 147.374
R3800 VGND.n968 VGND.n966 147.374
R3801 VGND.n1101 VGND.n1100 147.374
R3802 VGND.n971 VGND.n969 147.374
R3803 VGND.n1094 VGND.n1093 147.374
R3804 VGND.n974 VGND.n972 147.374
R3805 VGND.n1087 VGND.n1086 147.374
R3806 VGND.n977 VGND.n975 147.374
R3807 VGND.n1080 VGND.n1079 147.374
R3808 VGND.n980 VGND.n978 147.374
R3809 VGND.n1073 VGND.n1072 147.374
R3810 VGND.n983 VGND.n981 147.374
R3811 VGND.n1066 VGND.n1065 147.374
R3812 VGND.n986 VGND.n984 147.374
R3813 VGND.n1059 VGND.n1058 147.374
R3814 VGND.n989 VGND.n987 147.374
R3815 VGND.n1052 VGND.n1051 147.374
R3816 VGND.n992 VGND.n990 147.374
R3817 VGND.n1045 VGND.n1044 147.374
R3818 VGND.n995 VGND.n993 147.374
R3819 VGND.n1038 VGND.n1037 147.374
R3820 VGND.n998 VGND.n996 147.374
R3821 VGND.n1031 VGND.n1030 147.374
R3822 VGND.n1001 VGND.n999 147.374
R3823 VGND.n1024 VGND.n1023 147.374
R3824 VGND.n1004 VGND.n1002 147.374
R3825 VGND.n1017 VGND.n1016 147.374
R3826 VGND.n1008 VGND.n1005 147.374
R3827 VGND.n1010 VGND.n1009 147.374
R3828 VGND.n1193 VGND.n86 147.374
R3829 VGND.n1199 VGND.n88 147.374
R3830 VGND.n1203 VGND.n89 147.374
R3831 VGND.n1204 VGND.n84 147.374
R3832 VGND.n1210 VGND.n90 147.374
R3833 VGND.n1215 VGND.n83 147.374
R3834 VGND.n1221 VGND.n92 147.374
R3835 VGND.n1224 VGND.n93 147.374
R3836 VGND.n1230 VGND.n81 147.374
R3837 VGND.n1231 VGND.n95 147.374
R3838 VGND.n1238 VGND.n80 147.374
R3839 VGND.n1239 VGND.n96 147.374
R3840 VGND.n1246 VGND.n79 147.374
R3841 VGND.n1250 VGND.n78 147.374
R3842 VGND.n1253 VGND.n77 147.374
R3843 VGND.n1258 VGND.n97 147.374
R3844 VGND.n1264 VGND.n75 147.374
R3845 VGND.n1268 VGND.n74 147.374
R3846 VGND.n1272 VGND.n73 147.374
R3847 VGND.n1275 VGND.n72 147.374
R3848 VGND.n1280 VGND.n99 147.374
R3849 VGND.n1285 VGND.n70 147.374
R3850 VGND.n1290 VGND.n101 147.374
R3851 VGND.n1296 VGND.n68 147.374
R3852 VGND.n1300 VGND.n67 147.374
R3853 VGND.n1303 VGND.n66 147.374
R3854 VGND.n1309 VGND.n103 147.374
R3855 VGND.n1312 VGND.n104 147.374
R3856 VGND.n1318 VGND.n64 147.374
R3857 VGND.n1321 VGND.n63 147.374
R3858 VGND.n1326 VGND.n106 147.374
R3859 VGND.n1329 VGND.n108 147.374
R3860 VGND.n1333 VGND.n109 147.374
R3861 VGND.n1337 VGND.n110 147.374
R3862 VGND.n1344 VGND.n61 147.374
R3863 VGND.n1348 VGND.n60 147.374
R3864 VGND.n1352 VGND.n59 147.374
R3865 VGND.n1353 VGND.n111 147.374
R3866 VGND.n1360 VGND.n58 147.374
R3867 VGND.n1364 VGND.n57 147.374
R3868 VGND.n1365 VGND.n112 147.374
R3869 VGND.n1371 VGND.n56 147.374
R3870 VGND.n1376 VGND.n113 147.374
R3871 VGND.n160 VGND.n158 147.374
R3872 VGND.n288 VGND.n287 147.374
R3873 VGND.n163 VGND.n161 147.374
R3874 VGND.n281 VGND.n280 147.374
R3875 VGND.n166 VGND.n164 147.374
R3876 VGND.n274 VGND.n273 147.374
R3877 VGND.n169 VGND.n167 147.374
R3878 VGND.n267 VGND.n266 147.374
R3879 VGND.n172 VGND.n170 147.374
R3880 VGND.n260 VGND.n259 147.374
R3881 VGND.n175 VGND.n173 147.374
R3882 VGND.n253 VGND.n252 147.374
R3883 VGND.n178 VGND.n176 147.374
R3884 VGND.n246 VGND.n245 147.374
R3885 VGND.n181 VGND.n179 147.374
R3886 VGND.n239 VGND.n238 147.374
R3887 VGND.n184 VGND.n182 147.374
R3888 VGND.n232 VGND.n231 147.374
R3889 VGND.n187 VGND.n185 147.374
R3890 VGND.n225 VGND.n224 147.374
R3891 VGND.n190 VGND.n188 147.374
R3892 VGND.n218 VGND.n217 147.374
R3893 VGND.n193 VGND.n191 147.374
R3894 VGND.n211 VGND.n210 147.374
R3895 VGND.n196 VGND.n194 147.374
R3896 VGND.n204 VGND.n203 147.374
R3897 VGND.n198 VGND.n197 147.374
R3898 VGND.n300 VGND.n133 147.374
R3899 VGND.n303 VGND.n132 147.374
R3900 VGND.n308 VGND.n134 147.374
R3901 VGND.n313 VGND.n130 147.374
R3902 VGND.n316 VGND.n128 147.374
R3903 VGND.n323 VGND.n136 147.374
R3904 VGND.n326 VGND.n137 147.374
R3905 VGND.n331 VGND.n127 147.374
R3906 VGND.n337 VGND.n139 147.374
R3907 VGND.n340 VGND.n140 147.374
R3908 VGND.n345 VGND.n125 147.374
R3909 VGND.n350 VGND.n142 147.374
R3910 VGND.n356 VGND.n123 147.374
R3911 VGND.n360 VGND.n122 147.374
R3912 VGND.n361 VGND.n144 147.374
R3913 VGND.n368 VGND.n121 147.374
R3914 VGND.n369 VGND.n145 147.374
R3915 VGND.n375 VGND.n120 147.374
R3916 VGND.n381 VGND.n146 147.374
R3917 VGND.n384 VGND.n147 147.374
R3918 VGND.n387 VGND.n149 147.374
R3919 VGND.n394 VGND.n150 147.374
R3920 VGND.n1626 VGND.n54 147.374
R3921 VGND.n1428 VGND.n1427 147.374
R3922 VGND.n1620 VGND.n1426 147.374
R3923 VGND.n1616 VGND.n1425 147.374
R3924 VGND.n1612 VGND.n1424 147.374
R3925 VGND.n1608 VGND.n1423 147.374
R3926 VGND.n1604 VGND.n1422 147.374
R3927 VGND.n1600 VGND.n1421 147.374
R3928 VGND.n1596 VGND.n1420 147.374
R3929 VGND.n1592 VGND.n1419 147.374
R3930 VGND.n1588 VGND.n1418 147.374
R3931 VGND.n1584 VGND.n1417 147.374
R3932 VGND.n1580 VGND.n1416 147.374
R3933 VGND.n1576 VGND.n1415 147.374
R3934 VGND.n1572 VGND.n1414 147.374
R3935 VGND.n1568 VGND.n1413 147.374
R3936 VGND.n1564 VGND.n1412 147.374
R3937 VGND.n1560 VGND.n1411 147.374
R3938 VGND.n1556 VGND.n1410 147.374
R3939 VGND.n1552 VGND.n1409 147.374
R3940 VGND.n1548 VGND.n1408 147.374
R3941 VGND.n1544 VGND.n1407 147.374
R3942 VGND.n1540 VGND.n1406 147.374
R3943 VGND.n1536 VGND.n1405 147.374
R3944 VGND.n1532 VGND.n1404 147.374
R3945 VGND.n1528 VGND.n1403 147.374
R3946 VGND.n1524 VGND.n1402 147.374
R3947 VGND.n1520 VGND.n1401 147.374
R3948 VGND.n1516 VGND.n1400 147.374
R3949 VGND.n1512 VGND.n1399 147.374
R3950 VGND.n1508 VGND.n1398 147.374
R3951 VGND.n1504 VGND.n1397 147.374
R3952 VGND.n1500 VGND.n1396 147.374
R3953 VGND.n1496 VGND.n1395 147.374
R3954 VGND.n1492 VGND.n1394 147.374
R3955 VGND.n1488 VGND.n1393 147.374
R3956 VGND.n1484 VGND.n1392 147.374
R3957 VGND.n1480 VGND.n1391 147.374
R3958 VGND.n1476 VGND.n1390 147.374
R3959 VGND.n1472 VGND.n1389 147.374
R3960 VGND.n1468 VGND.n1388 147.374
R3961 VGND.n1464 VGND.n1387 147.374
R3962 VGND.n1460 VGND.n1386 147.374
R3963 VGND.n1456 VGND.n1385 147.374
R3964 VGND.n1452 VGND.n1384 147.374
R3965 VGND.n1448 VGND.n1383 147.374
R3966 VGND.n1444 VGND.n1382 147.374
R3967 VGND.n1440 VGND.n1381 147.374
R3968 VGND.n1436 VGND.n1380 147.374
R3969 VGND.n1432 VGND.n1379 147.374
R3970 VGND.n1697 VGND.n1696 147.374
R3971 VGND.n1702 VGND.n1701 147.374
R3972 VGND.n1694 VGND.n1692 147.374
R3973 VGND.n1710 VGND.n1709 147.374
R3974 VGND.n1690 VGND.n1688 147.374
R3975 VGND.n1718 VGND.n1717 147.374
R3976 VGND.n1687 VGND.n1685 147.374
R3977 VGND.n1725 VGND.n1724 147.374
R3978 VGND.n1728 VGND.n1727 147.374
R3979 VGND.n1734 VGND.n1733 147.374
R3980 VGND.n1737 VGND.n1736 147.374
R3981 VGND.n1743 VGND.n1742 147.374
R3982 VGND.n1746 VGND.n1745 147.374
R3983 VGND.n1752 VGND.n1751 147.374
R3984 VGND.n1675 VGND.n1673 147.374
R3985 VGND.n1760 VGND.n1759 147.374
R3986 VGND.n1766 VGND.n1765 147.374
R3987 VGND.n1769 VGND.n1768 147.374
R3988 VGND.n1775 VGND.n1774 147.374
R3989 VGND.n1777 VGND.n1776 147.374
R3990 VGND.n1783 VGND.n1782 147.374
R3991 VGND.n1665 VGND.n1663 147.374
R3992 VGND.n1790 VGND.n1789 147.374
R3993 VGND.n1662 VGND.n1660 147.374
R3994 VGND.n1796 VGND.n1795 147.374
R3995 VGND.n1659 VGND.n1657 147.374
R3996 VGND.n1804 VGND.n1803 147.374
R3997 VGND.n1655 VGND.n1653 147.374
R3998 VGND.n1812 VGND.n1811 147.374
R3999 VGND.n1652 VGND.n1650 147.374
R4000 VGND.n1819 VGND.n1818 147.374
R4001 VGND.n1821 VGND.n1647 147.374
R4002 VGND.n1827 VGND.n1826 147.374
R4003 VGND.n1833 VGND.n1832 147.374
R4004 VGND.n1644 VGND.n1642 147.374
R4005 VGND.n1840 VGND.n1839 147.374
R4006 VGND.n1641 VGND.n1639 147.374
R4007 VGND.n1847 VGND.n1846 147.374
R4008 VGND.n1849 VGND.n1848 147.374
R4009 VGND.n1855 VGND.n1854 147.374
R4010 VGND.n1636 VGND.n1634 147.374
R4011 VGND.n1861 VGND.n1860 147.374
R4012 VGND.n1864 VGND.n1863 147.374
R4013 VGND.n1870 VGND.n1869 147.374
R4014 VGND.n1872 VGND.n1871 147.374
R4015 VGND.n668 VGND.n666 147.374
R4016 VGND.n760 VGND.n665 147.374
R4017 VGND.n756 VGND.n664 147.374
R4018 VGND.n752 VGND.n663 147.374
R4019 VGND.n748 VGND.n662 147.374
R4020 VGND.n744 VGND.n661 147.374
R4021 VGND.n703 VGND.n686 147.374
R4022 VGND.n707 VGND.n687 147.374
R4023 VGND.n708 VGND.n685 147.374
R4024 VGND.n714 VGND.n688 147.374
R4025 VGND.n717 VGND.n690 147.374
R4026 VGND.n722 VGND.n721 147.374
R4027 VGND.n638 VGND.n637 147.374
R4028 VGND.n635 VGND.n634 147.374
R4029 VGND.n616 VGND.n614 147.374
R4030 VGND.n628 VGND.n627 147.374
R4031 VGND.n619 VGND.n617 147.374
R4032 VGND.n621 VGND.n620 147.374
R4033 VGND.n777 VGND.n767 147.374
R4034 VGND.n780 VGND.n769 147.374
R4035 VGND.n786 VGND.n659 147.374
R4036 VGND.n791 VGND.n770 147.374
R4037 VGND.n797 VGND.n772 147.374
R4038 VGND.n775 VGND.n767 147.374
R4039 VGND.n783 VGND.n769 147.374
R4040 VGND.n784 VGND.n659 147.374
R4041 VGND.n789 VGND.n770 147.374
R4042 VGND.n797 VGND.n796 147.374
R4043 VGND.n620 VGND.n609 147.374
R4044 VGND.n622 VGND.n619 147.374
R4045 VGND.n627 VGND.n626 147.374
R4046 VGND.n629 VGND.n616 147.374
R4047 VGND.n634 VGND.n633 147.374
R4048 VGND.n637 VGND.n636 147.374
R4049 VGND.n700 VGND.n686 147.374
R4050 VGND.n704 VGND.n687 147.374
R4051 VGND.n711 VGND.n685 147.374
R4052 VGND.n712 VGND.n688 147.374
R4053 VGND.n691 VGND.n690 147.374
R4054 VGND.n722 VGND.n683 147.374
R4055 VGND.n741 VGND.n661 147.374
R4056 VGND.n745 VGND.n662 147.374
R4057 VGND.n749 VGND.n663 147.374
R4058 VGND.n753 VGND.n664 147.374
R4059 VGND.n757 VGND.n665 147.374
R4060 VGND.n761 VGND.n666 147.374
R4061 VGND.n2035 VGND.n2034 147.374
R4062 VGND.n2032 VGND.n2031 147.374
R4063 VGND.n2040 VGND.n2039 147.374
R4064 VGND.n2043 VGND.n2042 147.374
R4065 VGND.n2040 VGND.n17 147.374
R4066 VGND.n2042 VGND.n2024 147.374
R4067 VGND.n2031 VGND.n2030 147.374
R4068 VGND.n2034 VGND.n2033 147.374
R4069 VGND.n1897 VGND.n1896 147.374
R4070 VGND.n1890 VGND.n1889 147.374
R4071 VGND.n1907 VGND.n1884 147.374
R4072 VGND.n1905 VGND.n1885 147.374
R4073 VGND.n1908 VGND.n1907 147.374
R4074 VGND.n1905 VGND.n1904 147.374
R4075 VGND.n1891 VGND.n1890 147.374
R4076 VGND.n1896 VGND.n1895 147.374
R4077 VGND.n1928 VGND.n1927 147.374
R4078 VGND.n1921 VGND.n1920 147.374
R4079 VGND.n1938 VGND.n1915 147.374
R4080 VGND.n1936 VGND.n1916 147.374
R4081 VGND.n1939 VGND.n1938 147.374
R4082 VGND.n1936 VGND.n1935 147.374
R4083 VGND.n1922 VGND.n1921 147.374
R4084 VGND.n1927 VGND.n1926 147.374
R4085 VGND.n1951 VGND.n1950 147.374
R4086 VGND.n1958 VGND.n1952 147.374
R4087 VGND.n1970 VGND.n1946 147.374
R4088 VGND.n1968 VGND.n1947 147.374
R4089 VGND.n1971 VGND.n1970 147.374
R4090 VGND.n1968 VGND.n1967 147.374
R4091 VGND.n1958 VGND.n1957 147.374
R4092 VGND.n1953 VGND.n1951 147.374
R4093 VGND.n1992 VGND.n1991 147.374
R4094 VGND.n1985 VGND.n1984 147.374
R4095 VGND.n2002 VGND.n1979 147.374
R4096 VGND.n2000 VGND.n1980 147.374
R4097 VGND.n2003 VGND.n2002 147.374
R4098 VGND.n2000 VGND.n1999 147.374
R4099 VGND.n1986 VGND.n1985 147.374
R4100 VGND.n1991 VGND.n1990 147.374
R4101 VGND.n40 VGND.n35 147.374
R4102 VGND.n42 VGND.n34 147.374
R4103 VGND.n2013 VGND.n2012 147.374
R4104 VGND.n2015 VGND.n2014 147.374
R4105 VGND.n2012 VGND.n2011 147.374
R4106 VGND.n2014 VGND.n30 147.374
R4107 VGND.n43 VGND.n42 147.374
R4108 VGND.n40 VGND.n39 147.374
R4109 VGND.n1696 VGND.n49 147.374
R4110 VGND.n1701 VGND.n1700 147.374
R4111 VGND.n1704 VGND.n1694 147.374
R4112 VGND.n1709 VGND.n1708 147.374
R4113 VGND.n1712 VGND.n1690 147.374
R4114 VGND.n1717 VGND.n1716 147.374
R4115 VGND.n1719 VGND.n1687 147.374
R4116 VGND.n1724 VGND.n1723 147.374
R4117 VGND.n1727 VGND.n1682 147.374
R4118 VGND.n1733 VGND.n1732 147.374
R4119 VGND.n1736 VGND.n1679 147.374
R4120 VGND.n1742 VGND.n1741 147.374
R4121 VGND.n1745 VGND.n1676 147.374
R4122 VGND.n1751 VGND.n1750 147.374
R4123 VGND.n1753 VGND.n1675 147.374
R4124 VGND.n1759 VGND.n1758 147.374
R4125 VGND.n1765 VGND.n1764 147.374
R4126 VGND.n1768 VGND.n1767 147.374
R4127 VGND.n1774 VGND.n1773 147.374
R4128 VGND.n1776 VGND.n1666 147.374
R4129 VGND.n1782 VGND.n1781 147.374
R4130 VGND.n1784 VGND.n1665 147.374
R4131 VGND.n1789 VGND.n1788 147.374
R4132 VGND.n1791 VGND.n1662 147.374
R4133 VGND.n1797 VGND.n1796 147.374
R4134 VGND.n1798 VGND.n1659 147.374
R4135 VGND.n1803 VGND.n1802 147.374
R4136 VGND.n1806 VGND.n1655 147.374
R4137 VGND.n1811 VGND.n1810 147.374
R4138 VGND.n1813 VGND.n1652 147.374
R4139 VGND.n1818 VGND.n1817 147.374
R4140 VGND.n1824 VGND.n1647 147.374
R4141 VGND.n1826 VGND.n1825 147.374
R4142 VGND.n1832 VGND.n1831 147.374
R4143 VGND.n1834 VGND.n1644 147.374
R4144 VGND.n1839 VGND.n1838 147.374
R4145 VGND.n1841 VGND.n1641 147.374
R4146 VGND.n1846 VGND.n1845 147.374
R4147 VGND.n1848 VGND.n1637 147.374
R4148 VGND.n1854 VGND.n1853 147.374
R4149 VGND.n1856 VGND.n1636 147.374
R4150 VGND.n1862 VGND.n1861 147.374
R4151 VGND.n1863 VGND.n1632 147.374
R4152 VGND.n1869 VGND.n1868 147.374
R4153 VGND.n1871 VGND.n52 147.374
R4154 VGND.n1429 VGND.n1379 147.374
R4155 VGND.n1433 VGND.n1380 147.374
R4156 VGND.n1437 VGND.n1381 147.374
R4157 VGND.n1441 VGND.n1382 147.374
R4158 VGND.n1445 VGND.n1383 147.374
R4159 VGND.n1449 VGND.n1384 147.374
R4160 VGND.n1453 VGND.n1385 147.374
R4161 VGND.n1457 VGND.n1386 147.374
R4162 VGND.n1461 VGND.n1387 147.374
R4163 VGND.n1465 VGND.n1388 147.374
R4164 VGND.n1469 VGND.n1389 147.374
R4165 VGND.n1473 VGND.n1390 147.374
R4166 VGND.n1477 VGND.n1391 147.374
R4167 VGND.n1481 VGND.n1392 147.374
R4168 VGND.n1485 VGND.n1393 147.374
R4169 VGND.n1489 VGND.n1394 147.374
R4170 VGND.n1493 VGND.n1395 147.374
R4171 VGND.n1497 VGND.n1396 147.374
R4172 VGND.n1501 VGND.n1397 147.374
R4173 VGND.n1505 VGND.n1398 147.374
R4174 VGND.n1509 VGND.n1399 147.374
R4175 VGND.n1513 VGND.n1400 147.374
R4176 VGND.n1517 VGND.n1401 147.374
R4177 VGND.n1521 VGND.n1402 147.374
R4178 VGND.n1525 VGND.n1403 147.374
R4179 VGND.n1529 VGND.n1404 147.374
R4180 VGND.n1533 VGND.n1405 147.374
R4181 VGND.n1537 VGND.n1406 147.374
R4182 VGND.n1541 VGND.n1407 147.374
R4183 VGND.n1545 VGND.n1408 147.374
R4184 VGND.n1549 VGND.n1409 147.374
R4185 VGND.n1553 VGND.n1410 147.374
R4186 VGND.n1557 VGND.n1411 147.374
R4187 VGND.n1561 VGND.n1412 147.374
R4188 VGND.n1565 VGND.n1413 147.374
R4189 VGND.n1569 VGND.n1414 147.374
R4190 VGND.n1573 VGND.n1415 147.374
R4191 VGND.n1577 VGND.n1416 147.374
R4192 VGND.n1581 VGND.n1417 147.374
R4193 VGND.n1585 VGND.n1418 147.374
R4194 VGND.n1589 VGND.n1419 147.374
R4195 VGND.n1593 VGND.n1420 147.374
R4196 VGND.n1597 VGND.n1421 147.374
R4197 VGND.n1601 VGND.n1422 147.374
R4198 VGND.n1605 VGND.n1423 147.374
R4199 VGND.n1609 VGND.n1424 147.374
R4200 VGND.n1613 VGND.n1425 147.374
R4201 VGND.n1617 VGND.n1426 147.374
R4202 VGND.n1621 VGND.n1427 147.374
R4203 VGND.n1626 VGND.n1625 147.374
R4204 VGND.n297 VGND.n133 147.374
R4205 VGND.n301 VGND.n132 147.374
R4206 VGND.n306 VGND.n134 147.374
R4207 VGND.n311 VGND.n130 147.374
R4208 VGND.n319 VGND.n128 147.374
R4209 VGND.n320 VGND.n136 147.374
R4210 VGND.n324 VGND.n137 147.374
R4211 VGND.n329 VGND.n127 147.374
R4212 VGND.n334 VGND.n139 147.374
R4213 VGND.n338 VGND.n140 147.374
R4214 VGND.n343 VGND.n125 147.374
R4215 VGND.n348 VGND.n142 147.374
R4216 VGND.n353 VGND.n123 147.374
R4217 VGND.n357 VGND.n122 147.374
R4218 VGND.n364 VGND.n144 147.374
R4219 VGND.n365 VGND.n121 147.374
R4220 VGND.n372 VGND.n145 147.374
R4221 VGND.n373 VGND.n120 147.374
R4222 VGND.n378 VGND.n146 147.374
R4223 VGND.n382 VGND.n147 147.374
R4224 VGND.n389 VGND.n149 147.374
R4225 VGND.n394 VGND.n393 147.374
R4226 VGND.n197 VGND.n154 147.374
R4227 VGND.n203 VGND.n202 147.374
R4228 VGND.n205 VGND.n196 147.374
R4229 VGND.n210 VGND.n209 147.374
R4230 VGND.n212 VGND.n193 147.374
R4231 VGND.n217 VGND.n216 147.374
R4232 VGND.n219 VGND.n190 147.374
R4233 VGND.n224 VGND.n223 147.374
R4234 VGND.n226 VGND.n187 147.374
R4235 VGND.n231 VGND.n230 147.374
R4236 VGND.n233 VGND.n184 147.374
R4237 VGND.n238 VGND.n237 147.374
R4238 VGND.n240 VGND.n181 147.374
R4239 VGND.n245 VGND.n244 147.374
R4240 VGND.n247 VGND.n178 147.374
R4241 VGND.n252 VGND.n251 147.374
R4242 VGND.n254 VGND.n175 147.374
R4243 VGND.n259 VGND.n258 147.374
R4244 VGND.n261 VGND.n172 147.374
R4245 VGND.n266 VGND.n265 147.374
R4246 VGND.n268 VGND.n169 147.374
R4247 VGND.n273 VGND.n272 147.374
R4248 VGND.n275 VGND.n166 147.374
R4249 VGND.n280 VGND.n279 147.374
R4250 VGND.n282 VGND.n163 147.374
R4251 VGND.n287 VGND.n286 147.374
R4252 VGND.n289 VGND.n160 147.374
R4253 VGND.n1191 VGND.n86 147.374
R4254 VGND.n1196 VGND.n88 147.374
R4255 VGND.n1200 VGND.n89 147.374
R4256 VGND.n1207 VGND.n84 147.374
R4257 VGND.n1208 VGND.n90 147.374
R4258 VGND.n1213 VGND.n83 147.374
R4259 VGND.n1218 VGND.n92 147.374
R4260 VGND.n1222 VGND.n93 147.374
R4261 VGND.n1227 VGND.n81 147.374
R4262 VGND.n1234 VGND.n95 147.374
R4263 VGND.n1235 VGND.n80 147.374
R4264 VGND.n1242 VGND.n96 147.374
R4265 VGND.n1243 VGND.n79 147.374
R4266 VGND.n1247 VGND.n78 147.374
R4267 VGND.n1251 VGND.n77 147.374
R4268 VGND.n1256 VGND.n97 147.374
R4269 VGND.n1261 VGND.n75 147.374
R4270 VGND.n1265 VGND.n74 147.374
R4271 VGND.n1269 VGND.n73 147.374
R4272 VGND.n1273 VGND.n72 147.374
R4273 VGND.n1278 VGND.n99 147.374
R4274 VGND.n1283 VGND.n70 147.374
R4275 VGND.n1288 VGND.n101 147.374
R4276 VGND.n1293 VGND.n68 147.374
R4277 VGND.n1297 VGND.n67 147.374
R4278 VGND.n1301 VGND.n66 147.374
R4279 VGND.n1306 VGND.n103 147.374
R4280 VGND.n1310 VGND.n104 147.374
R4281 VGND.n1315 VGND.n64 147.374
R4282 VGND.n1319 VGND.n63 147.374
R4283 VGND.n1324 VGND.n106 147.374
R4284 VGND.n1332 VGND.n108 147.374
R4285 VGND.n1336 VGND.n109 147.374
R4286 VGND.n1340 VGND.n110 147.374
R4287 VGND.n1341 VGND.n61 147.374
R4288 VGND.n1345 VGND.n60 147.374
R4289 VGND.n1349 VGND.n59 147.374
R4290 VGND.n1356 VGND.n111 147.374
R4291 VGND.n1357 VGND.n58 147.374
R4292 VGND.n1361 VGND.n57 147.374
R4293 VGND.n1368 VGND.n112 147.374
R4294 VGND.n1369 VGND.n56 147.374
R4295 VGND.n1376 VGND.n1375 147.374
R4296 VGND.n1009 VGND.n116 147.374
R4297 VGND.n1011 VGND.n1008 147.374
R4298 VGND.n1016 VGND.n1015 147.374
R4299 VGND.n1018 VGND.n1004 147.374
R4300 VGND.n1023 VGND.n1022 147.374
R4301 VGND.n1025 VGND.n1001 147.374
R4302 VGND.n1030 VGND.n1029 147.374
R4303 VGND.n1032 VGND.n998 147.374
R4304 VGND.n1037 VGND.n1036 147.374
R4305 VGND.n1039 VGND.n995 147.374
R4306 VGND.n1044 VGND.n1043 147.374
R4307 VGND.n1046 VGND.n992 147.374
R4308 VGND.n1051 VGND.n1050 147.374
R4309 VGND.n1053 VGND.n989 147.374
R4310 VGND.n1058 VGND.n1057 147.374
R4311 VGND.n1060 VGND.n986 147.374
R4312 VGND.n1065 VGND.n1064 147.374
R4313 VGND.n1067 VGND.n983 147.374
R4314 VGND.n1072 VGND.n1071 147.374
R4315 VGND.n1074 VGND.n980 147.374
R4316 VGND.n1079 VGND.n1078 147.374
R4317 VGND.n1081 VGND.n977 147.374
R4318 VGND.n1086 VGND.n1085 147.374
R4319 VGND.n1088 VGND.n974 147.374
R4320 VGND.n1093 VGND.n1092 147.374
R4321 VGND.n1095 VGND.n971 147.374
R4322 VGND.n1100 VGND.n1099 147.374
R4323 VGND.n1102 VGND.n968 147.374
R4324 VGND.n1107 VGND.n1106 147.374
R4325 VGND.n1109 VGND.n965 147.374
R4326 VGND.n1114 VGND.n1113 147.374
R4327 VGND.n1116 VGND.n962 147.374
R4328 VGND.n1121 VGND.n1120 147.374
R4329 VGND.n1123 VGND.n959 147.374
R4330 VGND.n1128 VGND.n1127 147.374
R4331 VGND.n1130 VGND.n956 147.374
R4332 VGND.n1135 VGND.n1134 147.374
R4333 VGND.n1137 VGND.n953 147.374
R4334 VGND.n1142 VGND.n1141 147.374
R4335 VGND.n1144 VGND.n950 147.374
R4336 VGND.n1149 VGND.n1148 147.374
R4337 VGND.n1151 VGND.n947 147.374
R4338 VGND.n1156 VGND.n1155 147.374
R4339 VGND.n1158 VGND.n944 147.374
R4340 VGND.n1163 VGND.n1162 147.374
R4341 VGND.n1165 VGND.n941 147.374
R4342 VGND.n1170 VGND.n1169 147.374
R4343 VGND.n1172 VGND.n938 147.374
R4344 VGND.n1177 VGND.n1176 147.374
R4345 VGND.n1180 VGND.n1179 147.374
R4346 VGND.n2021 VGND.n22 137.5
R4347 VGND.n2048 VGND.n2022 126.043
R4348 VGND.n810 VGND.t1 100.733
R4349 VGND.n5 VGND.t46 97.5478
R4350 VGND.n4 VGND.t53 97.5478
R4351 VGND.n3 VGND.t49 97.5478
R4352 VGND.n0 VGND.t43 92.0364
R4353 VGND.n2050 VGND.n15 86.9652
R4354 VGND.n2029 VGND.n14 86.9652
R4355 VGND.n2046 VGND.n2045 86.9652
R4356 VGND.n2037 VGND.n2036 86.9652
R4357 VGND.n1910 VGND.n1882 86.9652
R4358 VGND.n1892 VGND.n1881 86.9652
R4359 VGND.n1903 VGND.n1900 86.9652
R4360 VGND.n1899 VGND.n1887 86.9652
R4361 VGND.n1941 VGND.n1913 86.9652
R4362 VGND.n1923 VGND.n1912 86.9652
R4363 VGND.n1934 VGND.n1931 86.9652
R4364 VGND.n1930 VGND.n1918 86.9652
R4365 VGND.n1973 VGND.n1944 86.9652
R4366 VGND.n1956 VGND.n1943 86.9652
R4367 VGND.n1966 VGND.n1963 86.9652
R4368 VGND.n1962 VGND.n1949 86.9652
R4369 VGND.n2005 VGND.n1977 86.9652
R4370 VGND.n1987 VGND.n1976 86.9652
R4371 VGND.n1998 VGND.n1995 86.9652
R4372 VGND.n1994 VGND.n1982 86.9652
R4373 VGND.n2010 VGND.n2009 86.9652
R4374 VGND.n45 VGND.n33 86.9652
R4375 VGND.n2018 VGND.n2017 86.9652
R4376 VGND.n36 VGND.n31 86.9652
R4377 VGND.n1879 VGND.n47 85.0829
R4378 VGND.n1430 VGND.n46 85.0829
R4379 VGND.n1875 VGND.n1874 85.0829
R4380 VGND.n1630 VGND.n1629 85.0829
R4381 VGND.n1190 VGND.n1189 85.0829
R4382 VGND.n1374 VGND.n115 85.0829
R4383 VGND.n1006 VGND.n117 85.0829
R4384 VGND.n1184 VGND.n1183 85.0829
R4385 VGND.n298 VGND.n153 84.3299
R4386 VGND.n392 VGND.n152 84.3299
R4387 VGND.n199 VGND.n156 84.3299
R4388 VGND.n292 VGND.n291 84.3299
R4389 VGND.n816 VGND.n813 79.0593
R4390 VGND.n927 VGND.n926 79.0593
R4391 VGND.n585 VGND.n584 79.0593
R4392 VGND.n591 VGND.n590 79.0593
R4393 VGND.n776 VGND.n774 77.5534
R4394 VGND.n645 VGND.n608 77.5534
R4395 VGND.n795 VGND.n654 77.5534
R4396 VGND.n641 VGND.n640 77.5534
R4397 VGND.n701 VGND.n699 77.5534
R4398 VGND.n742 VGND.n670 77.5534
R4399 VGND.n726 VGND.n682 77.5534
R4400 VGND.n764 VGND.n669 77.5534
R4401 VGND.n724 VGND.n723 77.2064
R4402 VGND.n766 VGND.n660 77.2064
R4403 VGND.n799 VGND.n798 77.2064
R4404 VGND.n643 VGND.n610 77.2064
R4405 VGND.n923 VGND.n397 63.76
R4406 VGND.n588 VGND.n440 63.76
R4407 VGND.n2021 VGND.t50 57.2922
R4408 VGND.n724 VGND.n680 50.0005
R4409 VGND.n730 VGND.n680 50.0005
R4410 VGND.n731 VGND.n730 50.0005
R4411 VGND.n732 VGND.n673 50.0005
R4412 VGND.n738 VGND.n673 50.0005
R4413 VGND.n738 VGND.n660 50.0005
R4414 VGND.n800 VGND.n799 50.0005
R4415 VGND.n800 VGND.n601 50.0005
R4416 VGND.n806 VGND.n601 50.0005
R4417 VGND.n650 VGND.n649 50.0005
R4418 VGND.n650 VGND.n606 50.0005
R4419 VGND.n643 VGND.n606 50.0005
R4420 VGND.n0 VGND.n1880 44.7893
R4421 VGND.n0 VGND.n7 44.7893
R4422 VGND.n155 VGND.n0 43.8395
R4423 VGND.n610 VGND.n419 41.9123
R4424 VGND.n930 VGND.n397 40.5205
R4425 VGND.n594 VGND.t0 40.5205
R4426 VGND.n594 VGND.n440 40.5205
R4427 VGND.n931 VGND.n930 39.3288
R4428 VGND.n1 VGND.t11 32.8913
R4429 VGND.n1 VGND.t13 32.8913
R4430 VGND.n1377 VGND.n55 32.1214
R4431 VGND.n1186 VGND.n932 32.1214
R4432 VGND.n395 VGND.n118 32.1214
R4433 VGND.n294 VGND.n157 32.1214
R4434 VGND.n1877 VGND.n50 29.4786
R4435 VGND.n1627 VGND.n1378 29.4786
R4436 VGND.n813 VGND.n812 25.6005
R4437 VGND.n812 VGND.n811 25.6005
R4438 VGND.n811 VGND.n438 25.6005
R4439 VGND.n584 VGND.n438 25.6005
R4440 VGND.n817 VGND.n816 25.6005
R4441 VGND.n820 VGND.n817 25.6005
R4442 VGND.n822 VGND.n820 25.6005
R4443 VGND.n823 VGND.n822 25.6005
R4444 VGND.n825 VGND.n823 25.6005
R4445 VGND.n826 VGND.n825 25.6005
R4446 VGND.n829 VGND.n826 25.6005
R4447 VGND.n831 VGND.n829 25.6005
R4448 VGND.n832 VGND.n831 25.6005
R4449 VGND.n834 VGND.n832 25.6005
R4450 VGND.n835 VGND.n834 25.6005
R4451 VGND.n838 VGND.n835 25.6005
R4452 VGND.n839 VGND.n838 25.6005
R4453 VGND.n842 VGND.n839 25.6005
R4454 VGND.n844 VGND.n842 25.6005
R4455 VGND.n845 VGND.n844 25.6005
R4456 VGND.n847 VGND.n845 25.6005
R4457 VGND.n848 VGND.n847 25.6005
R4458 VGND.n851 VGND.n848 25.6005
R4459 VGND.n852 VGND.n851 25.6005
R4460 VGND.n855 VGND.n852 25.6005
R4461 VGND.n856 VGND.n855 25.6005
R4462 VGND.n859 VGND.n856 25.6005
R4463 VGND.n861 VGND.n859 25.6005
R4464 VGND.n862 VGND.n861 25.6005
R4465 VGND.n864 VGND.n862 25.6005
R4466 VGND.n866 VGND.n864 25.6005
R4467 VGND.n867 VGND.n866 25.6005
R4468 VGND.n869 VGND.n867 25.6005
R4469 VGND.n870 VGND.n869 25.6005
R4470 VGND.n873 VGND.n870 25.6005
R4471 VGND.n874 VGND.n873 25.6005
R4472 VGND.n877 VGND.n874 25.6005
R4473 VGND.n878 VGND.n877 25.6005
R4474 VGND.n881 VGND.n878 25.6005
R4475 VGND.n882 VGND.n881 25.6005
R4476 VGND.n885 VGND.n882 25.6005
R4477 VGND.n886 VGND.n885 25.6005
R4478 VGND.n889 VGND.n886 25.6005
R4479 VGND.n890 VGND.n889 25.6005
R4480 VGND.n893 VGND.n890 25.6005
R4481 VGND.n894 VGND.n893 25.6005
R4482 VGND.n897 VGND.n894 25.6005
R4483 VGND.n898 VGND.n897 25.6005
R4484 VGND.n901 VGND.n898 25.6005
R4485 VGND.n902 VGND.n901 25.6005
R4486 VGND.n905 VGND.n902 25.6005
R4487 VGND.n907 VGND.n905 25.6005
R4488 VGND.n908 VGND.n907 25.6005
R4489 VGND.n910 VGND.n908 25.6005
R4490 VGND.n911 VGND.n910 25.6005
R4491 VGND.n914 VGND.n911 25.6005
R4492 VGND.n915 VGND.n914 25.6005
R4493 VGND.n918 VGND.n915 25.6005
R4494 VGND.n919 VGND.n918 25.6005
R4495 VGND.n920 VGND.n919 25.6005
R4496 VGND.n920 VGND.n437 25.6005
R4497 VGND.n437 VGND.n401 25.6005
R4498 VGND.n926 VGND.n401 25.6005
R4499 VGND.n928 VGND.n927 25.6005
R4500 VGND.n928 VGND.n400 25.6005
R4501 VGND.n592 VGND.n400 25.6005
R4502 VGND.n592 VGND.n591 25.6005
R4503 VGND.n585 VGND.n583 25.6005
R4504 VGND.n583 VGND.n582 25.6005
R4505 VGND.n582 VGND.n580 25.6005
R4506 VGND.n580 VGND.n578 25.6005
R4507 VGND.n578 VGND.n577 25.6005
R4508 VGND.n577 VGND.n575 25.6005
R4509 VGND.n575 VGND.n572 25.6005
R4510 VGND.n572 VGND.n571 25.6005
R4511 VGND.n571 VGND.n568 25.6005
R4512 VGND.n568 VGND.n567 25.6005
R4513 VGND.n567 VGND.n564 25.6005
R4514 VGND.n564 VGND.n563 25.6005
R4515 VGND.n563 VGND.n561 25.6005
R4516 VGND.n561 VGND.n560 25.6005
R4517 VGND.n560 VGND.n558 25.6005
R4518 VGND.n558 VGND.n555 25.6005
R4519 VGND.n555 VGND.n554 25.6005
R4520 VGND.n554 VGND.n551 25.6005
R4521 VGND.n551 VGND.n550 25.6005
R4522 VGND.n550 VGND.n547 25.6005
R4523 VGND.n547 VGND.n546 25.6005
R4524 VGND.n546 VGND.n544 25.6005
R4525 VGND.n544 VGND.n543 25.6005
R4526 VGND.n543 VGND.n541 25.6005
R4527 VGND.n541 VGND.n538 25.6005
R4528 VGND.n538 VGND.n537 25.6005
R4529 VGND.n537 VGND.n534 25.6005
R4530 VGND.n534 VGND.n533 25.6005
R4531 VGND.n533 VGND.n530 25.6005
R4532 VGND.n530 VGND.n529 25.6005
R4533 VGND.n529 VGND.n526 25.6005
R4534 VGND.n526 VGND.n525 25.6005
R4535 VGND.n525 VGND.n522 25.6005
R4536 VGND.n522 VGND.n521 25.6005
R4537 VGND.n521 VGND.n518 25.6005
R4538 VGND.n518 VGND.n517 25.6005
R4539 VGND.n517 VGND.n514 25.6005
R4540 VGND.n514 VGND.n513 25.6005
R4541 VGND.n513 VGND.n510 25.6005
R4542 VGND.n510 VGND.n509 25.6005
R4543 VGND.n509 VGND.n506 25.6005
R4544 VGND.n506 VGND.n505 25.6005
R4545 VGND.n505 VGND.n502 25.6005
R4546 VGND.n502 VGND.n501 25.6005
R4547 VGND.n501 VGND.n498 25.6005
R4548 VGND.n498 VGND.n497 25.6005
R4549 VGND.n497 VGND.n494 25.6005
R4550 VGND.n494 VGND.n493 25.6005
R4551 VGND.n493 VGND.n491 25.6005
R4552 VGND.n491 VGND.n490 25.6005
R4553 VGND.n490 VGND.n488 25.6005
R4554 VGND.n488 VGND.n485 25.6005
R4555 VGND.n485 VGND.n484 25.6005
R4556 VGND.n484 VGND.n482 25.6005
R4557 VGND.n482 VGND.n481 25.6005
R4558 VGND.n481 VGND.n479 25.6005
R4559 VGND.n479 VGND.n476 25.6005
R4560 VGND.n476 VGND.n442 25.6005
R4561 VGND.n590 VGND.n442 25.6005
R4562 VGND.n778 VGND.n776 25.6005
R4563 VGND.n779 VGND.n778 25.6005
R4564 VGND.n781 VGND.n779 25.6005
R4565 VGND.n782 VGND.n781 25.6005
R4566 VGND.n785 VGND.n782 25.6005
R4567 VGND.n787 VGND.n785 25.6005
R4568 VGND.n788 VGND.n787 25.6005
R4569 VGND.n790 VGND.n788 25.6005
R4570 VGND.n792 VGND.n790 25.6005
R4571 VGND.n793 VGND.n792 25.6005
R4572 VGND.n794 VGND.n793 25.6005
R4573 VGND.n795 VGND.n794 25.6005
R4574 VGND.n774 VGND.n773 25.6005
R4575 VGND.n773 VGND.n598 25.6005
R4576 VGND.n808 VGND.n598 25.6005
R4577 VGND.n647 VGND.n597 25.6005
R4578 VGND.n647 VGND.n646 25.6005
R4579 VGND.n646 VGND.n645 25.6005
R4580 VGND.n618 VGND.n608 25.6005
R4581 VGND.n623 VGND.n618 25.6005
R4582 VGND.n624 VGND.n623 25.6005
R4583 VGND.n625 VGND.n624 25.6005
R4584 VGND.n625 VGND.n615 25.6005
R4585 VGND.n630 VGND.n615 25.6005
R4586 VGND.n631 VGND.n630 25.6005
R4587 VGND.n632 VGND.n631 25.6005
R4588 VGND.n632 VGND.n613 25.6005
R4589 VGND.n613 VGND.n612 25.6005
R4590 VGND.n639 VGND.n612 25.6005
R4591 VGND.n640 VGND.n639 25.6005
R4592 VGND.n802 VGND.n654 25.6005
R4593 VGND.n803 VGND.n802 25.6005
R4594 VGND.n804 VGND.n803 25.6005
R4595 VGND.n804 VGND.n653 25.6005
R4596 VGND.n653 VGND.n652 25.6005
R4597 VGND.n652 VGND.n604 25.6005
R4598 VGND.n641 VGND.n604 25.6005
R4599 VGND.n702 VGND.n701 25.6005
R4600 VGND.n705 VGND.n702 25.6005
R4601 VGND.n706 VGND.n705 25.6005
R4602 VGND.n709 VGND.n706 25.6005
R4603 VGND.n710 VGND.n709 25.6005
R4604 VGND.n713 VGND.n710 25.6005
R4605 VGND.n715 VGND.n713 25.6005
R4606 VGND.n716 VGND.n715 25.6005
R4607 VGND.n718 VGND.n716 25.6005
R4608 VGND.n719 VGND.n718 25.6005
R4609 VGND.n720 VGND.n719 25.6005
R4610 VGND.n720 VGND.n682 25.6005
R4611 VGND.n699 VGND.n698 25.6005
R4612 VGND.n698 VGND.n696 25.6005
R4613 VGND.n696 VGND.n695 25.6005
R4614 VGND.n693 VGND.n692 25.6005
R4615 VGND.n692 VGND.n672 25.6005
R4616 VGND.n672 VGND.n670 25.6005
R4617 VGND.n743 VGND.n742 25.6005
R4618 VGND.n746 VGND.n743 25.6005
R4619 VGND.n747 VGND.n746 25.6005
R4620 VGND.n750 VGND.n747 25.6005
R4621 VGND.n751 VGND.n750 25.6005
R4622 VGND.n754 VGND.n751 25.6005
R4623 VGND.n755 VGND.n754 25.6005
R4624 VGND.n758 VGND.n755 25.6005
R4625 VGND.n759 VGND.n758 25.6005
R4626 VGND.n762 VGND.n759 25.6005
R4627 VGND.n763 VGND.n762 25.6005
R4628 VGND.n764 VGND.n763 25.6005
R4629 VGND.n727 VGND.n726 25.6005
R4630 VGND.n728 VGND.n727 25.6005
R4631 VGND.n728 VGND.n675 25.6005
R4632 VGND.n734 VGND.n675 25.6005
R4633 VGND.n735 VGND.n734 25.6005
R4634 VGND.n736 VGND.n735 25.6005
R4635 VGND.n736 VGND.n669 25.6005
R4636 VGND.n2038 VGND.n15 25.6005
R4637 VGND.n2044 VGND.n2038 25.6005
R4638 VGND.n2045 VGND.n2044 25.6005
R4639 VGND.n2029 VGND.n2028 25.6005
R4640 VGND.n2028 VGND.n2025 25.6005
R4641 VGND.n2036 VGND.n2025 25.6005
R4642 VGND.n2046 VGND.n2037 25.6005
R4643 VGND.n1901 VGND.n1882 25.6005
R4644 VGND.n1902 VGND.n1901 25.6005
R4645 VGND.n1903 VGND.n1902 25.6005
R4646 VGND.n1893 VGND.n1892 25.6005
R4647 VGND.n1894 VGND.n1893 25.6005
R4648 VGND.n1894 VGND.n1887 25.6005
R4649 VGND.n1900 VGND.n1899 25.6005
R4650 VGND.n1932 VGND.n1913 25.6005
R4651 VGND.n1933 VGND.n1932 25.6005
R4652 VGND.n1934 VGND.n1933 25.6005
R4653 VGND.n1924 VGND.n1923 25.6005
R4654 VGND.n1925 VGND.n1924 25.6005
R4655 VGND.n1925 VGND.n1918 25.6005
R4656 VGND.n1931 VGND.n1930 25.6005
R4657 VGND.n1964 VGND.n1944 25.6005
R4658 VGND.n1965 VGND.n1964 25.6005
R4659 VGND.n1966 VGND.n1965 25.6005
R4660 VGND.n1956 VGND.n1955 25.6005
R4661 VGND.n1955 VGND.n1954 25.6005
R4662 VGND.n1954 VGND.n1949 25.6005
R4663 VGND.n1963 VGND.n1962 25.6005
R4664 VGND.n1996 VGND.n1977 25.6005
R4665 VGND.n1997 VGND.n1996 25.6005
R4666 VGND.n1998 VGND.n1997 25.6005
R4667 VGND.n1988 VGND.n1987 25.6005
R4668 VGND.n1989 VGND.n1988 25.6005
R4669 VGND.n1989 VGND.n1982 25.6005
R4670 VGND.n1995 VGND.n1994 25.6005
R4671 VGND.n2010 VGND.n32 25.6005
R4672 VGND.n2016 VGND.n32 25.6005
R4673 VGND.n2017 VGND.n2016 25.6005
R4674 VGND.n37 VGND.n33 25.6005
R4675 VGND.n38 VGND.n37 25.6005
R4676 VGND.n38 VGND.n36 25.6005
R4677 VGND.n2018 VGND.n31 25.6005
R4678 VGND.n1698 VGND.n47 25.6005
R4679 VGND.n1699 VGND.n1698 25.6005
R4680 VGND.n1699 VGND.n1695 25.6005
R4681 VGND.n1695 VGND.n1693 25.6005
R4682 VGND.n1705 VGND.n1693 25.6005
R4683 VGND.n1706 VGND.n1705 25.6005
R4684 VGND.n1707 VGND.n1706 25.6005
R4685 VGND.n1707 VGND.n1691 25.6005
R4686 VGND.n1691 VGND.n1689 25.6005
R4687 VGND.n1713 VGND.n1689 25.6005
R4688 VGND.n1714 VGND.n1713 25.6005
R4689 VGND.n1715 VGND.n1714 25.6005
R4690 VGND.n1715 VGND.n1686 25.6005
R4691 VGND.n1720 VGND.n1686 25.6005
R4692 VGND.n1721 VGND.n1720 25.6005
R4693 VGND.n1722 VGND.n1721 25.6005
R4694 VGND.n1722 VGND.n1684 25.6005
R4695 VGND.n1684 VGND.n1683 25.6005
R4696 VGND.n1729 VGND.n1683 25.6005
R4697 VGND.n1730 VGND.n1729 25.6005
R4698 VGND.n1731 VGND.n1730 25.6005
R4699 VGND.n1731 VGND.n1681 25.6005
R4700 VGND.n1681 VGND.n1680 25.6005
R4701 VGND.n1738 VGND.n1680 25.6005
R4702 VGND.n1739 VGND.n1738 25.6005
R4703 VGND.n1740 VGND.n1739 25.6005
R4704 VGND.n1740 VGND.n1678 25.6005
R4705 VGND.n1678 VGND.n1677 25.6005
R4706 VGND.n1747 VGND.n1677 25.6005
R4707 VGND.n1748 VGND.n1747 25.6005
R4708 VGND.n1749 VGND.n1748 25.6005
R4709 VGND.n1749 VGND.n1674 25.6005
R4710 VGND.n1754 VGND.n1674 25.6005
R4711 VGND.n1755 VGND.n1754 25.6005
R4712 VGND.n1756 VGND.n1755 25.6005
R4713 VGND.n1756 VGND.n1672 25.6005
R4714 VGND.n1761 VGND.n1672 25.6005
R4715 VGND.n1762 VGND.n1761 25.6005
R4716 VGND.n1763 VGND.n1762 25.6005
R4717 VGND.n1763 VGND.n1670 25.6005
R4718 VGND.n1670 VGND.n1669 25.6005
R4719 VGND.n1770 VGND.n1669 25.6005
R4720 VGND.n1771 VGND.n1770 25.6005
R4721 VGND.n1772 VGND.n1771 25.6005
R4722 VGND.n1772 VGND.n1667 25.6005
R4723 VGND.n1778 VGND.n1667 25.6005
R4724 VGND.n1779 VGND.n1778 25.6005
R4725 VGND.n1780 VGND.n1779 25.6005
R4726 VGND.n1780 VGND.n1664 25.6005
R4727 VGND.n1785 VGND.n1664 25.6005
R4728 VGND.n1786 VGND.n1785 25.6005
R4729 VGND.n1787 VGND.n1786 25.6005
R4730 VGND.n1787 VGND.n1661 25.6005
R4731 VGND.n1792 VGND.n1661 25.6005
R4732 VGND.n1793 VGND.n1792 25.6005
R4733 VGND.n1794 VGND.n1793 25.6005
R4734 VGND.n1794 VGND.n1658 25.6005
R4735 VGND.n1799 VGND.n1658 25.6005
R4736 VGND.n1800 VGND.n1799 25.6005
R4737 VGND.n1801 VGND.n1800 25.6005
R4738 VGND.n1801 VGND.n1656 25.6005
R4739 VGND.n1656 VGND.n1654 25.6005
R4740 VGND.n1807 VGND.n1654 25.6005
R4741 VGND.n1808 VGND.n1807 25.6005
R4742 VGND.n1809 VGND.n1808 25.6005
R4743 VGND.n1809 VGND.n1651 25.6005
R4744 VGND.n1814 VGND.n1651 25.6005
R4745 VGND.n1815 VGND.n1814 25.6005
R4746 VGND.n1816 VGND.n1815 25.6005
R4747 VGND.n1816 VGND.n1649 25.6005
R4748 VGND.n1649 VGND.n1648 25.6005
R4749 VGND.n1822 VGND.n1648 25.6005
R4750 VGND.n1823 VGND.n1822 25.6005
R4751 VGND.n1823 VGND.n1646 25.6005
R4752 VGND.n1828 VGND.n1646 25.6005
R4753 VGND.n1829 VGND.n1828 25.6005
R4754 VGND.n1830 VGND.n1829 25.6005
R4755 VGND.n1830 VGND.n1643 25.6005
R4756 VGND.n1835 VGND.n1643 25.6005
R4757 VGND.n1836 VGND.n1835 25.6005
R4758 VGND.n1837 VGND.n1836 25.6005
R4759 VGND.n1837 VGND.n1640 25.6005
R4760 VGND.n1842 VGND.n1640 25.6005
R4761 VGND.n1843 VGND.n1842 25.6005
R4762 VGND.n1844 VGND.n1843 25.6005
R4763 VGND.n1844 VGND.n1638 25.6005
R4764 VGND.n1850 VGND.n1638 25.6005
R4765 VGND.n1851 VGND.n1850 25.6005
R4766 VGND.n1852 VGND.n1851 25.6005
R4767 VGND.n1852 VGND.n1635 25.6005
R4768 VGND.n1857 VGND.n1635 25.6005
R4769 VGND.n1858 VGND.n1857 25.6005
R4770 VGND.n1859 VGND.n1858 25.6005
R4771 VGND.n1859 VGND.n1633 25.6005
R4772 VGND.n1865 VGND.n1633 25.6005
R4773 VGND.n1866 VGND.n1865 25.6005
R4774 VGND.n1867 VGND.n1866 25.6005
R4775 VGND.n1867 VGND.n1631 25.6005
R4776 VGND.n1873 VGND.n1631 25.6005
R4777 VGND.n1874 VGND.n1873 25.6005
R4778 VGND.n1431 VGND.n1430 25.6005
R4779 VGND.n1434 VGND.n1431 25.6005
R4780 VGND.n1435 VGND.n1434 25.6005
R4781 VGND.n1438 VGND.n1435 25.6005
R4782 VGND.n1439 VGND.n1438 25.6005
R4783 VGND.n1442 VGND.n1439 25.6005
R4784 VGND.n1443 VGND.n1442 25.6005
R4785 VGND.n1446 VGND.n1443 25.6005
R4786 VGND.n1447 VGND.n1446 25.6005
R4787 VGND.n1450 VGND.n1447 25.6005
R4788 VGND.n1451 VGND.n1450 25.6005
R4789 VGND.n1454 VGND.n1451 25.6005
R4790 VGND.n1455 VGND.n1454 25.6005
R4791 VGND.n1458 VGND.n1455 25.6005
R4792 VGND.n1459 VGND.n1458 25.6005
R4793 VGND.n1462 VGND.n1459 25.6005
R4794 VGND.n1463 VGND.n1462 25.6005
R4795 VGND.n1466 VGND.n1463 25.6005
R4796 VGND.n1467 VGND.n1466 25.6005
R4797 VGND.n1470 VGND.n1467 25.6005
R4798 VGND.n1471 VGND.n1470 25.6005
R4799 VGND.n1474 VGND.n1471 25.6005
R4800 VGND.n1475 VGND.n1474 25.6005
R4801 VGND.n1478 VGND.n1475 25.6005
R4802 VGND.n1479 VGND.n1478 25.6005
R4803 VGND.n1482 VGND.n1479 25.6005
R4804 VGND.n1483 VGND.n1482 25.6005
R4805 VGND.n1486 VGND.n1483 25.6005
R4806 VGND.n1487 VGND.n1486 25.6005
R4807 VGND.n1490 VGND.n1487 25.6005
R4808 VGND.n1491 VGND.n1490 25.6005
R4809 VGND.n1494 VGND.n1491 25.6005
R4810 VGND.n1495 VGND.n1494 25.6005
R4811 VGND.n1498 VGND.n1495 25.6005
R4812 VGND.n1499 VGND.n1498 25.6005
R4813 VGND.n1502 VGND.n1499 25.6005
R4814 VGND.n1503 VGND.n1502 25.6005
R4815 VGND.n1506 VGND.n1503 25.6005
R4816 VGND.n1507 VGND.n1506 25.6005
R4817 VGND.n1510 VGND.n1507 25.6005
R4818 VGND.n1511 VGND.n1510 25.6005
R4819 VGND.n1514 VGND.n1511 25.6005
R4820 VGND.n1515 VGND.n1514 25.6005
R4821 VGND.n1518 VGND.n1515 25.6005
R4822 VGND.n1519 VGND.n1518 25.6005
R4823 VGND.n1522 VGND.n1519 25.6005
R4824 VGND.n1523 VGND.n1522 25.6005
R4825 VGND.n1526 VGND.n1523 25.6005
R4826 VGND.n1527 VGND.n1526 25.6005
R4827 VGND.n1530 VGND.n1527 25.6005
R4828 VGND.n1531 VGND.n1530 25.6005
R4829 VGND.n1534 VGND.n1531 25.6005
R4830 VGND.n1535 VGND.n1534 25.6005
R4831 VGND.n1538 VGND.n1535 25.6005
R4832 VGND.n1539 VGND.n1538 25.6005
R4833 VGND.n1542 VGND.n1539 25.6005
R4834 VGND.n1543 VGND.n1542 25.6005
R4835 VGND.n1546 VGND.n1543 25.6005
R4836 VGND.n1547 VGND.n1546 25.6005
R4837 VGND.n1550 VGND.n1547 25.6005
R4838 VGND.n1551 VGND.n1550 25.6005
R4839 VGND.n1554 VGND.n1551 25.6005
R4840 VGND.n1555 VGND.n1554 25.6005
R4841 VGND.n1558 VGND.n1555 25.6005
R4842 VGND.n1559 VGND.n1558 25.6005
R4843 VGND.n1562 VGND.n1559 25.6005
R4844 VGND.n1563 VGND.n1562 25.6005
R4845 VGND.n1566 VGND.n1563 25.6005
R4846 VGND.n1567 VGND.n1566 25.6005
R4847 VGND.n1570 VGND.n1567 25.6005
R4848 VGND.n1571 VGND.n1570 25.6005
R4849 VGND.n1574 VGND.n1571 25.6005
R4850 VGND.n1575 VGND.n1574 25.6005
R4851 VGND.n1578 VGND.n1575 25.6005
R4852 VGND.n1579 VGND.n1578 25.6005
R4853 VGND.n1582 VGND.n1579 25.6005
R4854 VGND.n1583 VGND.n1582 25.6005
R4855 VGND.n1586 VGND.n1583 25.6005
R4856 VGND.n1587 VGND.n1586 25.6005
R4857 VGND.n1590 VGND.n1587 25.6005
R4858 VGND.n1591 VGND.n1590 25.6005
R4859 VGND.n1594 VGND.n1591 25.6005
R4860 VGND.n1595 VGND.n1594 25.6005
R4861 VGND.n1598 VGND.n1595 25.6005
R4862 VGND.n1599 VGND.n1598 25.6005
R4863 VGND.n1602 VGND.n1599 25.6005
R4864 VGND.n1603 VGND.n1602 25.6005
R4865 VGND.n1606 VGND.n1603 25.6005
R4866 VGND.n1607 VGND.n1606 25.6005
R4867 VGND.n1610 VGND.n1607 25.6005
R4868 VGND.n1611 VGND.n1610 25.6005
R4869 VGND.n1614 VGND.n1611 25.6005
R4870 VGND.n1615 VGND.n1614 25.6005
R4871 VGND.n1618 VGND.n1615 25.6005
R4872 VGND.n1619 VGND.n1618 25.6005
R4873 VGND.n1622 VGND.n1619 25.6005
R4874 VGND.n1623 VGND.n1622 25.6005
R4875 VGND.n1624 VGND.n1623 25.6005
R4876 VGND.n1624 VGND.n53 25.6005
R4877 VGND.n1629 VGND.n53 25.6005
R4878 VGND.n1875 VGND.n1630 25.6005
R4879 VGND.n299 VGND.n298 25.6005
R4880 VGND.n302 VGND.n299 25.6005
R4881 VGND.n304 VGND.n302 25.6005
R4882 VGND.n305 VGND.n304 25.6005
R4883 VGND.n307 VGND.n305 25.6005
R4884 VGND.n309 VGND.n307 25.6005
R4885 VGND.n310 VGND.n309 25.6005
R4886 VGND.n312 VGND.n310 25.6005
R4887 VGND.n314 VGND.n312 25.6005
R4888 VGND.n315 VGND.n314 25.6005
R4889 VGND.n317 VGND.n315 25.6005
R4890 VGND.n318 VGND.n317 25.6005
R4891 VGND.n321 VGND.n318 25.6005
R4892 VGND.n322 VGND.n321 25.6005
R4893 VGND.n325 VGND.n322 25.6005
R4894 VGND.n327 VGND.n325 25.6005
R4895 VGND.n328 VGND.n327 25.6005
R4896 VGND.n330 VGND.n328 25.6005
R4897 VGND.n332 VGND.n330 25.6005
R4898 VGND.n333 VGND.n332 25.6005
R4899 VGND.n335 VGND.n333 25.6005
R4900 VGND.n336 VGND.n335 25.6005
R4901 VGND.n339 VGND.n336 25.6005
R4902 VGND.n341 VGND.n339 25.6005
R4903 VGND.n342 VGND.n341 25.6005
R4904 VGND.n344 VGND.n342 25.6005
R4905 VGND.n346 VGND.n344 25.6005
R4906 VGND.n347 VGND.n346 25.6005
R4907 VGND.n349 VGND.n347 25.6005
R4908 VGND.n351 VGND.n349 25.6005
R4909 VGND.n352 VGND.n351 25.6005
R4910 VGND.n354 VGND.n352 25.6005
R4911 VGND.n355 VGND.n354 25.6005
R4912 VGND.n358 VGND.n355 25.6005
R4913 VGND.n359 VGND.n358 25.6005
R4914 VGND.n362 VGND.n359 25.6005
R4915 VGND.n363 VGND.n362 25.6005
R4916 VGND.n366 VGND.n363 25.6005
R4917 VGND.n367 VGND.n366 25.6005
R4918 VGND.n370 VGND.n367 25.6005
R4919 VGND.n371 VGND.n370 25.6005
R4920 VGND.n374 VGND.n371 25.6005
R4921 VGND.n376 VGND.n374 25.6005
R4922 VGND.n377 VGND.n376 25.6005
R4923 VGND.n379 VGND.n377 25.6005
R4924 VGND.n380 VGND.n379 25.6005
R4925 VGND.n383 VGND.n380 25.6005
R4926 VGND.n385 VGND.n383 25.6005
R4927 VGND.n386 VGND.n385 25.6005
R4928 VGND.n388 VGND.n386 25.6005
R4929 VGND.n390 VGND.n388 25.6005
R4930 VGND.n391 VGND.n390 25.6005
R4931 VGND.n392 VGND.n391 25.6005
R4932 VGND.n292 VGND.n152 25.6005
R4933 VGND.n200 VGND.n199 25.6005
R4934 VGND.n201 VGND.n200 25.6005
R4935 VGND.n201 VGND.n195 25.6005
R4936 VGND.n206 VGND.n195 25.6005
R4937 VGND.n207 VGND.n206 25.6005
R4938 VGND.n208 VGND.n207 25.6005
R4939 VGND.n208 VGND.n192 25.6005
R4940 VGND.n213 VGND.n192 25.6005
R4941 VGND.n214 VGND.n213 25.6005
R4942 VGND.n215 VGND.n214 25.6005
R4943 VGND.n215 VGND.n189 25.6005
R4944 VGND.n220 VGND.n189 25.6005
R4945 VGND.n221 VGND.n220 25.6005
R4946 VGND.n222 VGND.n221 25.6005
R4947 VGND.n222 VGND.n186 25.6005
R4948 VGND.n227 VGND.n186 25.6005
R4949 VGND.n228 VGND.n227 25.6005
R4950 VGND.n229 VGND.n228 25.6005
R4951 VGND.n229 VGND.n183 25.6005
R4952 VGND.n234 VGND.n183 25.6005
R4953 VGND.n235 VGND.n234 25.6005
R4954 VGND.n236 VGND.n235 25.6005
R4955 VGND.n236 VGND.n180 25.6005
R4956 VGND.n241 VGND.n180 25.6005
R4957 VGND.n242 VGND.n241 25.6005
R4958 VGND.n243 VGND.n242 25.6005
R4959 VGND.n243 VGND.n177 25.6005
R4960 VGND.n248 VGND.n177 25.6005
R4961 VGND.n249 VGND.n248 25.6005
R4962 VGND.n250 VGND.n249 25.6005
R4963 VGND.n250 VGND.n174 25.6005
R4964 VGND.n255 VGND.n174 25.6005
R4965 VGND.n256 VGND.n255 25.6005
R4966 VGND.n257 VGND.n256 25.6005
R4967 VGND.n257 VGND.n171 25.6005
R4968 VGND.n262 VGND.n171 25.6005
R4969 VGND.n263 VGND.n262 25.6005
R4970 VGND.n264 VGND.n263 25.6005
R4971 VGND.n264 VGND.n168 25.6005
R4972 VGND.n269 VGND.n168 25.6005
R4973 VGND.n270 VGND.n269 25.6005
R4974 VGND.n271 VGND.n270 25.6005
R4975 VGND.n271 VGND.n165 25.6005
R4976 VGND.n276 VGND.n165 25.6005
R4977 VGND.n277 VGND.n276 25.6005
R4978 VGND.n278 VGND.n277 25.6005
R4979 VGND.n278 VGND.n162 25.6005
R4980 VGND.n283 VGND.n162 25.6005
R4981 VGND.n284 VGND.n283 25.6005
R4982 VGND.n285 VGND.n284 25.6005
R4983 VGND.n285 VGND.n159 25.6005
R4984 VGND.n290 VGND.n159 25.6005
R4985 VGND.n291 VGND.n290 25.6005
R4986 VGND.n1192 VGND.n1190 25.6005
R4987 VGND.n1194 VGND.n1192 25.6005
R4988 VGND.n1195 VGND.n1194 25.6005
R4989 VGND.n1197 VGND.n1195 25.6005
R4990 VGND.n1198 VGND.n1197 25.6005
R4991 VGND.n1201 VGND.n1198 25.6005
R4992 VGND.n1202 VGND.n1201 25.6005
R4993 VGND.n1205 VGND.n1202 25.6005
R4994 VGND.n1206 VGND.n1205 25.6005
R4995 VGND.n1209 VGND.n1206 25.6005
R4996 VGND.n1211 VGND.n1209 25.6005
R4997 VGND.n1212 VGND.n1211 25.6005
R4998 VGND.n1214 VGND.n1212 25.6005
R4999 VGND.n1216 VGND.n1214 25.6005
R5000 VGND.n1217 VGND.n1216 25.6005
R5001 VGND.n1219 VGND.n1217 25.6005
R5002 VGND.n1220 VGND.n1219 25.6005
R5003 VGND.n1223 VGND.n1220 25.6005
R5004 VGND.n1225 VGND.n1223 25.6005
R5005 VGND.n1226 VGND.n1225 25.6005
R5006 VGND.n1228 VGND.n1226 25.6005
R5007 VGND.n1229 VGND.n1228 25.6005
R5008 VGND.n1232 VGND.n1229 25.6005
R5009 VGND.n1233 VGND.n1232 25.6005
R5010 VGND.n1236 VGND.n1233 25.6005
R5011 VGND.n1237 VGND.n1236 25.6005
R5012 VGND.n1240 VGND.n1237 25.6005
R5013 VGND.n1241 VGND.n1240 25.6005
R5014 VGND.n1244 VGND.n1241 25.6005
R5015 VGND.n1245 VGND.n1244 25.6005
R5016 VGND.n1248 VGND.n1245 25.6005
R5017 VGND.n1249 VGND.n1248 25.6005
R5018 VGND.n1252 VGND.n1249 25.6005
R5019 VGND.n1254 VGND.n1252 25.6005
R5020 VGND.n1255 VGND.n1254 25.6005
R5021 VGND.n1257 VGND.n1255 25.6005
R5022 VGND.n1259 VGND.n1257 25.6005
R5023 VGND.n1260 VGND.n1259 25.6005
R5024 VGND.n1262 VGND.n1260 25.6005
R5025 VGND.n1263 VGND.n1262 25.6005
R5026 VGND.n1266 VGND.n1263 25.6005
R5027 VGND.n1267 VGND.n1266 25.6005
R5028 VGND.n1270 VGND.n1267 25.6005
R5029 VGND.n1271 VGND.n1270 25.6005
R5030 VGND.n1274 VGND.n1271 25.6005
R5031 VGND.n1276 VGND.n1274 25.6005
R5032 VGND.n1277 VGND.n1276 25.6005
R5033 VGND.n1279 VGND.n1277 25.6005
R5034 VGND.n1281 VGND.n1279 25.6005
R5035 VGND.n1282 VGND.n1281 25.6005
R5036 VGND.n1284 VGND.n1282 25.6005
R5037 VGND.n1286 VGND.n1284 25.6005
R5038 VGND.n1287 VGND.n1286 25.6005
R5039 VGND.n1289 VGND.n1287 25.6005
R5040 VGND.n1291 VGND.n1289 25.6005
R5041 VGND.n1292 VGND.n1291 25.6005
R5042 VGND.n1294 VGND.n1292 25.6005
R5043 VGND.n1295 VGND.n1294 25.6005
R5044 VGND.n1298 VGND.n1295 25.6005
R5045 VGND.n1299 VGND.n1298 25.6005
R5046 VGND.n1302 VGND.n1299 25.6005
R5047 VGND.n1304 VGND.n1302 25.6005
R5048 VGND.n1305 VGND.n1304 25.6005
R5049 VGND.n1307 VGND.n1305 25.6005
R5050 VGND.n1308 VGND.n1307 25.6005
R5051 VGND.n1311 VGND.n1308 25.6005
R5052 VGND.n1313 VGND.n1311 25.6005
R5053 VGND.n1314 VGND.n1313 25.6005
R5054 VGND.n1316 VGND.n1314 25.6005
R5055 VGND.n1317 VGND.n1316 25.6005
R5056 VGND.n1320 VGND.n1317 25.6005
R5057 VGND.n1322 VGND.n1320 25.6005
R5058 VGND.n1323 VGND.n1322 25.6005
R5059 VGND.n1325 VGND.n1323 25.6005
R5060 VGND.n1327 VGND.n1325 25.6005
R5061 VGND.n1328 VGND.n1327 25.6005
R5062 VGND.n1330 VGND.n1328 25.6005
R5063 VGND.n1331 VGND.n1330 25.6005
R5064 VGND.n1334 VGND.n1331 25.6005
R5065 VGND.n1335 VGND.n1334 25.6005
R5066 VGND.n1338 VGND.n1335 25.6005
R5067 VGND.n1339 VGND.n1338 25.6005
R5068 VGND.n1342 VGND.n1339 25.6005
R5069 VGND.n1343 VGND.n1342 25.6005
R5070 VGND.n1346 VGND.n1343 25.6005
R5071 VGND.n1347 VGND.n1346 25.6005
R5072 VGND.n1350 VGND.n1347 25.6005
R5073 VGND.n1351 VGND.n1350 25.6005
R5074 VGND.n1354 VGND.n1351 25.6005
R5075 VGND.n1355 VGND.n1354 25.6005
R5076 VGND.n1358 VGND.n1355 25.6005
R5077 VGND.n1359 VGND.n1358 25.6005
R5078 VGND.n1362 VGND.n1359 25.6005
R5079 VGND.n1363 VGND.n1362 25.6005
R5080 VGND.n1366 VGND.n1363 25.6005
R5081 VGND.n1367 VGND.n1366 25.6005
R5082 VGND.n1370 VGND.n1367 25.6005
R5083 VGND.n1372 VGND.n1370 25.6005
R5084 VGND.n1373 VGND.n1372 25.6005
R5085 VGND.n1374 VGND.n1373 25.6005
R5086 VGND.n1184 VGND.n115 25.6005
R5087 VGND.n1007 VGND.n1006 25.6005
R5088 VGND.n1012 VGND.n1007 25.6005
R5089 VGND.n1013 VGND.n1012 25.6005
R5090 VGND.n1014 VGND.n1013 25.6005
R5091 VGND.n1014 VGND.n1003 25.6005
R5092 VGND.n1019 VGND.n1003 25.6005
R5093 VGND.n1020 VGND.n1019 25.6005
R5094 VGND.n1021 VGND.n1020 25.6005
R5095 VGND.n1021 VGND.n1000 25.6005
R5096 VGND.n1026 VGND.n1000 25.6005
R5097 VGND.n1027 VGND.n1026 25.6005
R5098 VGND.n1028 VGND.n1027 25.6005
R5099 VGND.n1028 VGND.n997 25.6005
R5100 VGND.n1033 VGND.n997 25.6005
R5101 VGND.n1034 VGND.n1033 25.6005
R5102 VGND.n1035 VGND.n1034 25.6005
R5103 VGND.n1035 VGND.n994 25.6005
R5104 VGND.n1040 VGND.n994 25.6005
R5105 VGND.n1041 VGND.n1040 25.6005
R5106 VGND.n1042 VGND.n1041 25.6005
R5107 VGND.n1042 VGND.n991 25.6005
R5108 VGND.n1047 VGND.n991 25.6005
R5109 VGND.n1048 VGND.n1047 25.6005
R5110 VGND.n1049 VGND.n1048 25.6005
R5111 VGND.n1049 VGND.n988 25.6005
R5112 VGND.n1054 VGND.n988 25.6005
R5113 VGND.n1055 VGND.n1054 25.6005
R5114 VGND.n1056 VGND.n1055 25.6005
R5115 VGND.n1056 VGND.n985 25.6005
R5116 VGND.n1061 VGND.n985 25.6005
R5117 VGND.n1062 VGND.n1061 25.6005
R5118 VGND.n1063 VGND.n1062 25.6005
R5119 VGND.n1063 VGND.n982 25.6005
R5120 VGND.n1068 VGND.n982 25.6005
R5121 VGND.n1069 VGND.n1068 25.6005
R5122 VGND.n1070 VGND.n1069 25.6005
R5123 VGND.n1070 VGND.n979 25.6005
R5124 VGND.n1075 VGND.n979 25.6005
R5125 VGND.n1076 VGND.n1075 25.6005
R5126 VGND.n1077 VGND.n1076 25.6005
R5127 VGND.n1077 VGND.n976 25.6005
R5128 VGND.n1082 VGND.n976 25.6005
R5129 VGND.n1083 VGND.n1082 25.6005
R5130 VGND.n1084 VGND.n1083 25.6005
R5131 VGND.n1084 VGND.n973 25.6005
R5132 VGND.n1089 VGND.n973 25.6005
R5133 VGND.n1090 VGND.n1089 25.6005
R5134 VGND.n1091 VGND.n1090 25.6005
R5135 VGND.n1091 VGND.n970 25.6005
R5136 VGND.n1096 VGND.n970 25.6005
R5137 VGND.n1097 VGND.n1096 25.6005
R5138 VGND.n1098 VGND.n1097 25.6005
R5139 VGND.n1098 VGND.n967 25.6005
R5140 VGND.n1103 VGND.n967 25.6005
R5141 VGND.n1104 VGND.n1103 25.6005
R5142 VGND.n1105 VGND.n1104 25.6005
R5143 VGND.n1105 VGND.n964 25.6005
R5144 VGND.n1110 VGND.n964 25.6005
R5145 VGND.n1111 VGND.n1110 25.6005
R5146 VGND.n1112 VGND.n1111 25.6005
R5147 VGND.n1112 VGND.n961 25.6005
R5148 VGND.n1117 VGND.n961 25.6005
R5149 VGND.n1118 VGND.n1117 25.6005
R5150 VGND.n1119 VGND.n1118 25.6005
R5151 VGND.n1119 VGND.n958 25.6005
R5152 VGND.n1124 VGND.n958 25.6005
R5153 VGND.n1125 VGND.n1124 25.6005
R5154 VGND.n1126 VGND.n1125 25.6005
R5155 VGND.n1126 VGND.n955 25.6005
R5156 VGND.n1131 VGND.n955 25.6005
R5157 VGND.n1132 VGND.n1131 25.6005
R5158 VGND.n1133 VGND.n1132 25.6005
R5159 VGND.n1133 VGND.n952 25.6005
R5160 VGND.n1138 VGND.n952 25.6005
R5161 VGND.n1139 VGND.n1138 25.6005
R5162 VGND.n1140 VGND.n1139 25.6005
R5163 VGND.n1140 VGND.n949 25.6005
R5164 VGND.n1145 VGND.n949 25.6005
R5165 VGND.n1146 VGND.n1145 25.6005
R5166 VGND.n1147 VGND.n1146 25.6005
R5167 VGND.n1147 VGND.n946 25.6005
R5168 VGND.n1152 VGND.n946 25.6005
R5169 VGND.n1153 VGND.n1152 25.6005
R5170 VGND.n1154 VGND.n1153 25.6005
R5171 VGND.n1154 VGND.n943 25.6005
R5172 VGND.n1159 VGND.n943 25.6005
R5173 VGND.n1160 VGND.n1159 25.6005
R5174 VGND.n1161 VGND.n1160 25.6005
R5175 VGND.n1161 VGND.n940 25.6005
R5176 VGND.n1166 VGND.n940 25.6005
R5177 VGND.n1167 VGND.n1166 25.6005
R5178 VGND.n1168 VGND.n1167 25.6005
R5179 VGND.n1168 VGND.n937 25.6005
R5180 VGND.n1173 VGND.n937 25.6005
R5181 VGND.n1174 VGND.n1173 25.6005
R5182 VGND.n1175 VGND.n1174 25.6005
R5183 VGND.n1175 VGND.n935 25.6005
R5184 VGND.n935 VGND.n934 25.6005
R5185 VGND.n1182 VGND.n934 25.6005
R5186 VGND.n1183 VGND.n1182 25.6005
R5187 VGND.n6 VGND.n0 25.0863
R5188 VGND.t12 VGND.n731 25.0005
R5189 VGND.n732 VGND.t12 25.0005
R5190 VGND.n806 VGND.t10 25.0005
R5191 VGND.n649 VGND.t10 25.0005
R5192 VGND.n811 VGND.n810 23.0653
R5193 VGND.n1 VGND.n809 21.4141
R5194 VGND.n694 VGND.n1 21.4141
R5195 VGND.n3 VGND.n2051 20.9453
R5196 VGND.n4 VGND.n1911 20.9453
R5197 VGND.n5 VGND.n1942 20.9453
R5198 VGND.n1975 VGND.n1974 20.9453
R5199 VGND.n2007 VGND.n2006 20.9453
R5200 VGND.n2008 VGND.n6 20.9453
R5201 VGND.n809 VGND.n808 12.8005
R5202 VGND.n809 VGND.n597 12.8005
R5203 VGND.n695 VGND.n694 12.8005
R5204 VGND.n694 VGND.n693 12.8005
R5205 VGND.n2051 VGND.n2050 12.8005
R5206 VGND.n2051 VGND.n14 12.8005
R5207 VGND.n1911 VGND.n1910 12.8005
R5208 VGND.n1911 VGND.n1881 12.8005
R5209 VGND.n1942 VGND.n1941 12.8005
R5210 VGND.n1942 VGND.n1912 12.8005
R5211 VGND.n1974 VGND.n1973 12.8005
R5212 VGND.n1974 VGND.n1943 12.8005
R5213 VGND.n2006 VGND.n2005 12.8005
R5214 VGND.n2006 VGND.n1976 12.8005
R5215 VGND.n2009 VGND.n2008 12.8005
R5216 VGND.n2008 VGND.n45 12.8005
R5217 VGND.n1880 VGND.n1879 12.8005
R5218 VGND.n1880 VGND.n46 12.8005
R5219 VGND.n155 VGND.n153 12.8005
R5220 VGND.n156 VGND.n155 12.8005
R5221 VGND.n1189 VGND.n7 12.8005
R5222 VGND.n117 VGND.n7 12.8005
R5223 VGND.t42 VGND.n55 9.58042
R5224 VGND.n1186 VGND.t42 9.58042
R5225 VGND.t44 VGND.n118 9.58042
R5226 VGND.n294 VGND.t44 9.58042
R5227 VGND.n1877 VGND.t41 8.79223
R5228 VGND.n1378 VGND.t41 8.79223
R5229 VGND.t4 VGND.n2053 4.9615
R5230 VGND.n2052 VGND.t6 4.9615
R5231 VGND.t6 VGND.n13 4.9615
R5232 VGND.t4 VGND.n2059 4.9615
R5233 VGND.n2054 VGND.t4 4.9615
R5234 VGND.t6 VGND.n12 4.9615
R5235 VGND.n2058 VGND.t4 4.9615
R5236 VGND.t6 VGND.n10 4.9615
R5237 VGND.t4 VGND.n2057 4.9615
R5238 VGND.t6 VGND.n11 4.9615
R5239 VGND.n2056 VGND.t4 4.9615
R5240 VGND.t6 VGND.n8 4.9615
R5241 VGND.t4 VGND.n2055 4.9615
R5242 VGND.t6 VGND.n9 4.9615
R5243 VGND.n2 VGND.n3 4.87272
R5244 VGND.n6 VGND.n1 4.42372
R5245 VGND.n2 VGND.t6 4.28402
R5246 VGND VGND.t4 4.28402
R5247 VGND.n2059 VGND.t2 4.22668
R5248 VGND.t8 VGND.n12 4.22668
R5249 VGND.n810 VGND.n1 4.22006
R5250 VGND.t8 VGND.n2 3.46784
R5251 VGND.t2 VGND 3.46784
R5252 VGND.n2053 VGND.t2 3.4105
R5253 VGND.n2052 VGND.t8 3.4105
R5254 VGND.t8 VGND.n13 3.4105
R5255 VGND.t2 VGND.n2058 3.4105
R5256 VGND.n2057 VGND.t2 3.4105
R5257 VGND.t2 VGND.n2056 3.4105
R5258 VGND.n2055 VGND.t2 3.4105
R5259 VGND.t2 VGND.n2054 3.4105
R5260 VGND.t8 VGND.n9 3.4105
R5261 VGND.t8 VGND.n8 3.4105
R5262 VGND.t8 VGND.n11 3.4105
R5263 VGND.t8 VGND.n10 3.4105
R5264 VGND.n2 VGND 2.3505
R5265 VGND.n3 VGND.n4 1.72906
R5266 VGND.n6 VGND.n2007 1.6925
R5267 VGND.n2053 VGND.n2052 1.5515
R5268 VGND.n2059 VGND.n13 1.5515
R5269 VGND.n2054 VGND.n12 1.5515
R5270 VGND.n2058 VGND.n10 1.5515
R5271 VGND.n2057 VGND.n11 1.5515
R5272 VGND.n2056 VGND.n8 1.5515
R5273 VGND.n2055 VGND.n9 1.5515
R5274 VGND.n1975 VGND.n5 1.5515
R5275 VGND.n2007 VGND.n1975 1.5515
R5276 VGND.n5 VGND.n4 1.53583
R5277 VGND.n931 VGND.t0 1.19227
R5278 MIRROR.n4 MIRROR.n3 121.276
R5279 MIRROR.n8 MIRROR.n7 121.276
R5280 MIRROR.n16 MIRROR.n15 117.434
R5281 MIRROR.n15 MIRROR.n1 98.1243
R5282 MIRROR.n3 MIRROR.n2 67.22
R5283 MIRROR.n7 MIRROR.n6 67.22
R5284 MIRROR.n3 MIRROR.t3 48.2005
R5285 MIRROR.n7 MIRROR.t0 48.2005
R5286 MIRROR.n11 MIRROR.n10 37.4189
R5287 MIRROR MIRROR.n16 31.9563
R5288 MIRROR MIRROR.n10 31.7518
R5289 MIRROR.n12 MIRROR.n11 31.437
R5290 MIRROR.n4 MIRROR 28.3423
R5291 MIRROR.n8 MIRROR 28.3423
R5292 MIRROR.n14 MIRROR.n0 15.3507
R5293 MIRROR.n0 MIRROR.n13 15.1197
R5294 MIRROR.n0 MIRROR.n5 14.8871
R5295 MIRROR.n0 MIRROR.n9 14.1194
R5296 MIRROR.n0 MIRROR 12.808
R5297 MIRROR.n15 MIRROR.t2 7.14175
R5298 MIRROR.n5 MIRROR.n4 6.19208
R5299 MIRROR.n9 MIRROR.n8 6.19208
R5300 MIRROR MIRROR.n1 5.58763
R5301 MIRROR.n12 MIRROR 5.42725
R5302 MIRROR.n11 MIRROR.t1 4.3505
R5303 MIRROR.n5 MIRROR.n2 3.97386
R5304 MIRROR.n9 MIRROR.n6 3.97386
R5305 MIRROR MIRROR.n2 3.22741
R5306 MIRROR MIRROR.n6 3.22741
R5307 MIRROR.n13 MIRROR.n10 2.52519
R5308 MIRROR.n16 MIRROR.n14 2.51099
R5309 MIRROR.n13 MIRROR.n12 1.69124
R5310 MIRROR.n14 MIRROR.n1 1.67339
R5311 AMP.n2 AMP.t3 482
R5312 AMP.n2 AMP.n1 170.624
R5313 AMP.n3 AMP.n2 170.624
R5314 AMP.n15 AMP.n14 117.434
R5315 AMP.n14 AMP.n0 98.1243
R5316 AMP.n11 AMP.n10 61.2913
R5317 AMP.n10 AMP.t2 56.9009
R5318 AMP.n6 AMP.n5 37.4189
R5319 AMP AMP.n15 31.9563
R5320 AMP AMP.n5 31.7518
R5321 AMP.n7 AMP.n6 31.437
R5322 AMP.n13 AMP.n12 15.9757
R5323 AMP.n9 AMP.n8 15.7447
R5324 AMP.n9 AMP.n4 14.999
R5325 AMP AMP.n1 12.8005
R5326 AMP.n3 AMP 12.8005
R5327 AMP.n4 AMP.n1 10.0806
R5328 AMP.n4 AMP.n3 10.0806
R5329 AMP.n14 AMP.t0 7.14175
R5330 AMP.n11 AMP 7.04267
R5331 AMP.n10 AMP 6.17712
R5332 AMP AMP.n0 5.58763
R5333 AMP.n7 AMP 5.42725
R5334 AMP.n6 AMP.t1 4.3505
R5335 AMP.n12 AMP.n11 4.00594
R5336 AMP.n8 AMP.n5 2.52519
R5337 AMP.n15 AMP.n13 2.51099
R5338 AMP.n12 AMP.n9 2.33483
R5339 AMP.n8 AMP.n7 1.69124
R5340 AMP.n13 AMP.n0 1.67339
R5341 TAIL.n10 TAIL.n9 117.434
R5342 TAIL.n3 TAIL.n2 117.434
R5343 TAIL.n9 TAIL.n1 98.1243
R5344 TAIL.n4 TAIL.n3 98.1243
R5345 TAIL TAIL.n10 31.9563
R5346 TAIL TAIL.n2 31.9563
R5347 TAIL TAIL.n0 5.23741
R5348 TAIL.n7 TAIL.n0 17.184
R5349 TAIL.n8 TAIL.n7 15.6632
R5350 TAIL.n6 TAIL.n5 15.44
R5351 TAIL.n6 TAIL 10.2804
R5352 TAIL.n9 TAIL.t1 7.14175
R5353 TAIL.n0 TAIL.t2 60.703
R5354 TAIL.n3 TAIL.t0 7.14175
R5355 TAIL TAIL.n1 5.58763
R5356 TAIL.n4 TAIL 5.58763
R5357 TAIL.n10 TAIL.n8 2.51099
R5358 TAIL.n5 TAIL.n2 2.51099
R5359 TAIL.n8 TAIL.n1 1.67339
R5360 TAIL.n5 TAIL.n4 1.67339
R5361 TAIL.n7 TAIL.n6 1.18594
R5362 HOLD.n8 HOLD.t0 407.813
R5363 HOLD.t0 HOLD.n7 401.517
R5364 HOLD.n27 HOLD.n2 197.048
R5365 HOLD.n4 HOLD.n3 168.895
R5366 HOLD.n5 HOLD.n4 168.895
R5367 HOLD.n4 HOLD.t2 96.4005
R5368 HOLD.n2 HOLD.n1 92.1489
R5369 HOLD.n17 HOLD 23.62
R5370 HOLD.n13 HOLD 23.62
R5371 HOLD HOLD.n7 21.688
R5372 HOLD.n2 HOLD.t1 17.4005
R5373 HOLD.n11 HOLD.n10 16.5317
R5374 HOLD.n22 HOLD.n21 16.5317
R5375 HOLD.n26 HOLD.n1 16.0734
R5376 HOLD.n0 HOLD.n6 15.3011
R5377 HOLD.n25 HOLD.n24 15.223
R5378 HOLD.n0 HOLD.n9 14.5583
R5379 HOLD.n26 HOLD.n0 14.1487
R5380 HOLD HOLD.n27 13.5534
R5381 HOLD HOLD.n3 12.8005
R5382 HOLD.n5 HOLD 12.8005
R5383 HOLD.n9 HOLD.n7 12.6768
R5384 HOLD.n21 HOLD 12.5575
R5385 HOLD.n10 HOLD 12.5575
R5386 HOLD.n19 HOLD 12.2231
R5387 HOLD.n15 HOLD 12.2231
R5388 HOLD.n15 HOLD.n14 11.3661
R5389 HOLD.n19 HOLD.n18 11.3661
R5390 HOLD.n16 HOLD.n12 11.0224
R5391 HOLD.n6 HOLD.n3 10.0806
R5392 HOLD.n6 HOLD.n5 10.0806
R5393 HOLD.n27 HOLD.n26 9.32224
R5394 HOLD.n23 HOLD 7.08874
R5395 HOLD.n22 HOLD 7.08874
R5396 HOLD.n21 HOLD 7.08874
R5397 HOLD.n18 HOLD 7.08874
R5398 HOLD.n17 HOLD 7.08874
R5399 HOLD.n14 HOLD 7.08874
R5400 HOLD.n13 HOLD 7.08874
R5401 HOLD.n12 HOLD 7.08874
R5402 HOLD.n11 HOLD 7.08874
R5403 HOLD.n10 HOLD 7.08874
R5404 HOLD.n0 HOLD.n25 6.75806
R5405 HOLD HOLD.n1 6.33895
R5406 HOLD.n24 HOLD.n20 6.21925
R5407 HOLD.n20 HOLD.n16 6.21925
R5408 HOLD.n12 HOLD.n11 5.46925
R5409 HOLD.n14 HOLD.n13 5.46925
R5410 HOLD.n18 HOLD.n17 5.46925
R5411 HOLD.n23 HOLD.n22 5.46925
R5412 HOLD.n24 HOLD.n23 4.80362
R5413 HOLD.n8 HOLD 4.62024
R5414 HOLD.n20 HOLD.n19 4.5005
R5415 HOLD.n16 HOLD.n15 4.5005
R5416 HOLD.n9 HOLD.n8 2.70094
R5417 HOLD.n25 HOLD 2.34267
R5418 SAMPLE.n6 SAMPLE.t2 407.813
R5419 SAMPLE.n29 SAMPLE.t1 407.813
R5420 SAMPLE.n36 SAMPLE.t0 407.813
R5421 SAMPLE.t2 SAMPLE.n5 401.517
R5422 SAMPLE.t1 SAMPLE.n28 401.517
R5423 SAMPLE.t0 SAMPLE.n35 401.517
R5424 SAMPLE.n39 SAMPLE.n4 197.048
R5425 SAMPLE.n26 SAMPLE.n25 197.048
R5426 SAMPLE.n33 SAMPLE.n32 197.048
R5427 SAMPLE.n4 SAMPLE.n3 92.1489
R5428 SAMPLE.n25 SAMPLE.n24 92.1489
R5429 SAMPLE.n32 SAMPLE.n31 92.1489
R5430 SAMPLE.n19 SAMPLE 23.5193
R5431 SAMPLE.n8 SAMPLE 23.5193
R5432 SAMPLE SAMPLE.n5 21.688
R5433 SAMPLE SAMPLE.n28 21.688
R5434 SAMPLE SAMPLE.n35 21.688
R5435 SAMPLE.n4 SAMPLE.t3 17.4005
R5436 SAMPLE.n25 SAMPLE.t4 17.4005
R5437 SAMPLE.n32 SAMPLE.t5 17.4005
R5438 SAMPLE.n12 SAMPLE.n11 16.5317
R5439 SAMPLE.n16 SAMPLE.n15 16.5317
R5440 SAMPLE.n38 SAMPLE.n3 16.0734
R5441 SAMPLE.n27 SAMPLE.n24 16.0734
R5442 SAMPLE.n34 SAMPLE.n31 16.0734
R5443 SAMPLE.n23 SAMPLE.n22 15.0667
R5444 SAMPLE.n2 SAMPLE.n7 14.5965
R5445 SAMPLE.n1 SAMPLE.n30 13.9333
R5446 SAMPLE.n2 SAMPLE.n37 13.9333
R5447 SAMPLE.n10 SAMPLE.n9 13.7099
R5448 SAMPLE.n21 SAMPLE.n20 13.7099
R5449 SAMPLE SAMPLE.n39 13.5534
R5450 SAMPLE.n26 SAMPLE 13.5534
R5451 SAMPLE.n33 SAMPLE 13.5534
R5452 SAMPLE.n38 SAMPLE.n2 13.5237
R5453 SAMPLE.n0 SAMPLE.n27 13.5237
R5454 SAMPLE.n1 SAMPLE.n34 13.5237
R5455 SAMPLE.n7 SAMPLE.n5 12.6768
R5456 SAMPLE.n30 SAMPLE.n28 12.6768
R5457 SAMPLE.n37 SAMPLE.n35 12.6768
R5458 SAMPLE.n15 SAMPLE 12.4568
R5459 SAMPLE.n11 SAMPLE 12.4568
R5460 SAMPLE.n14 SAMPLE.n10 10.7193
R5461 SAMPLE.n21 SAMPLE 9.77865
R5462 SAMPLE.n10 SAMPLE 9.77865
R5463 SAMPLE.n39 SAMPLE.n38 9.32224
R5464 SAMPLE.n27 SAMPLE.n26 9.32224
R5465 SAMPLE.n34 SAMPLE.n33 9.32224
R5466 SAMPLE.n14 SAMPLE.n13 7.14737
R5467 SAMPLE.n18 SAMPLE.n17 7.14737
R5468 SAMPLE.n20 SAMPLE 6.98802
R5469 SAMPLE.n19 SAMPLE 6.98802
R5470 SAMPLE.n17 SAMPLE 6.98802
R5471 SAMPLE.n16 SAMPLE 6.98802
R5472 SAMPLE.n15 SAMPLE 6.98802
R5473 SAMPLE.n13 SAMPLE 6.98802
R5474 SAMPLE.n12 SAMPLE 6.98802
R5475 SAMPLE.n11 SAMPLE 6.98802
R5476 SAMPLE.n9 SAMPLE 6.98802
R5477 SAMPLE.n8 SAMPLE 6.98802
R5478 SAMPLE SAMPLE.n3 6.33895
R5479 SAMPLE SAMPLE.n24 6.33895
R5480 SAMPLE SAMPLE.n31 6.33895
R5481 SAMPLE.n22 SAMPLE.n18 6.21925
R5482 SAMPLE.n18 SAMPLE.n14 6.21925
R5483 SAMPLE.n9 SAMPLE.n8 5.46925
R5484 SAMPLE.n13 SAMPLE.n12 5.46925
R5485 SAMPLE.n17 SAMPLE.n16 5.46925
R5486 SAMPLE.n20 SAMPLE.n19 5.46925
R5487 SAMPLE.n6 SAMPLE 4.62024
R5488 SAMPLE.n29 SAMPLE 4.62024
R5489 SAMPLE.n36 SAMPLE 4.62024
R5490 SAMPLE.n22 SAMPLE.n21 4.5005
R5491 SAMPLE.n0 SAMPLE.n23 3.53594
R5492 SAMPLE.n7 SAMPLE.n6 2.70094
R5493 SAMPLE.n30 SAMPLE.n29 2.70094
R5494 SAMPLE.n37 SAMPLE.n36 2.70094
R5495 SAMPLE.n23 SAMPLE 1.55933
R5496 SAMPLE.n1 SAMPLE.n0 1.53583
R5497 SAMPLE.n2 SAMPLE.n1 1.32694
R5498 S_BAR.n7 S_BAR.t1 407.813
R5499 S_BAR.t1 S_BAR.n1 401.517
R5500 S_BAR S_BAR.t2 333.784
R5501 S_BAR.n4 S_BAR.n3 197.048
R5502 S_BAR.n3 S_BAR.n2 92.1489
R5503 S_BAR.n0 S_BAR 26.0144
R5504 S_BAR S_BAR.n1 21.688
R5505 S_BAR.n3 S_BAR.t0 17.4005
R5506 S_BAR.n5 S_BAR.n2 16.0734
R5507 S_BAR.n4 S_BAR 13.5534
R5508 S_BAR.n6 S_BAR.n1 12.6768
R5509 S_BAR.n6 S_BAR.n0 12.594
R5510 S_BAR.n0 S_BAR.n5 12.5862
R5511 S_BAR.n5 S_BAR.n4 9.32224
R5512 S_BAR S_BAR.n2 6.33895
R5513 S_BAR S_BAR.n7 4.62024
R5514 S_BAR.n0 S_BAR 4.10256
R5515 S_BAR.n7 S_BAR.n6 2.70094
R5516 L_BAR.n7 L_BAR.t1 407.813
R5517 L_BAR.t1 L_BAR.n1 401.517
R5518 L_BAR L_BAR.t2 333.784
R5519 L_BAR.n4 L_BAR.n3 197.048
R5520 L_BAR.n3 L_BAR.n2 92.1489
R5521 L_BAR.n0 L_BAR 25.7019
R5522 L_BAR L_BAR.n1 21.688
R5523 L_BAR.n3 L_BAR.t0 17.4005
R5524 L_BAR.n5 L_BAR.n2 16.0734
R5525 L_BAR.n4 L_BAR 13.5534
R5526 L_BAR.n6 L_BAR.n1 12.6768
R5527 L_BAR.n6 L_BAR.n0 12.2815
R5528 L_BAR.n0 L_BAR.n5 12.2737
R5529 L_BAR.n5 L_BAR.n4 9.32224
R5530 L_BAR L_BAR.n2 6.33895
R5531 L_BAR L_BAR.n7 4.62024
R5532 L_BAR.n7 L_BAR.n6 2.70094
R5533 L_BAR.n0 L_BAR 2.53589
R5534 H_BAR.n6 H_BAR.t1 407.813
R5535 H_BAR.t1 H_BAR.n0 401.517
R5536 H_BAR H_BAR.t2 333.784
R5537 H_BAR.n3 H_BAR.n2 197.048
R5538 H_BAR.n2 H_BAR.n1 92.1489
R5539 H_BAR H_BAR.n0 21.688
R5540 H_BAR.n2 H_BAR.t0 17.4005
R5541 H_BAR.n4 H_BAR.n1 16.0734
R5542 H_BAR.n3 H_BAR 13.5534
R5543 H_BAR H_BAR.n4 12.7288
R5544 H_BAR.n5 H_BAR.n0 12.6768
R5545 H_BAR.n5 H_BAR 11.969
R5546 H_BAR.n4 H_BAR.n3 9.32224
R5547 H_BAR H_BAR.n1 6.33895
R5548 H_BAR H_BAR.n6 4.62024
R5549 H_BAR.n6 H_BAR.n5 2.70094
R5550 BIAS.n4 BIAS.t3 289.2
R5551 BIAS.n2 BIAS.n1 117.434
R5552 BIAS.n5 BIAS.n4 117.15
R5553 BIAS.n9 BIAS.n8 117.15
R5554 BIAS.n13 BIAS.n12 117.15
R5555 BIAS.n18 BIAS.n2 98.1243
R5556 BIAS.n4 BIAS.n3 65.9614
R5557 BIAS.n8 BIAS.n7 65.9614
R5558 BIAS.n12 BIAS.n11 65.9614
R5559 BIAS.n15 BIAS.t0 56.9009
R5560 BIAS.n16 BIAS.n15 55.5762
R5561 BIAS.n8 BIAS.t4 48.2005
R5562 BIAS.n12 BIAS.t1 48.2005
R5563 BIAS BIAS.n1 31.9563
R5564 BIAS.n5 BIAS 28.3694
R5565 BIAS.n9 BIAS 28.3694
R5566 BIAS.n13 BIAS 28.3694
R5567 BIAS.n0 BIAS.n6 14.58
R5568 BIAS.n17 BIAS.n0 14.5025
R5569 BIAS.n0 BIAS.n10 13.4881
R5570 BIAS.n0 BIAS.n14 13.4881
R5571 BIAS.n2 BIAS.t2 7.14175
R5572 BIAS.n15 BIAS 6.17712
R5573 BIAS.n6 BIAS.n5 6.16394
R5574 BIAS.n10 BIAS.n9 6.16394
R5575 BIAS.n14 BIAS.n13 6.16394
R5576 BIAS BIAS.n18 5.58763
R5577 BIAS.n16 BIAS 5.476
R5578 BIAS.n0 BIAS.n16 4.96683
R5579 BIAS.n6 BIAS.n3 3.92068
R5580 BIAS.n10 BIAS.n7 3.92068
R5581 BIAS.n14 BIAS.n11 3.92068
R5582 BIAS BIAS.n3 3.27839
R5583 BIAS BIAS.n7 3.27839
R5584 BIAS BIAS.n11 3.27839
R5585 BIAS.n17 BIAS.n1 2.51099
R5586 BIAS.n18 BIAS.n17 1.67339
C0 AMP SAMPLE 0.90636f
C1 vout vref_high 1.07787f
C2 BIAS TAIL 1.14771f
C3 MIRROR L_BAR 0.30518f
C4 charge_high vref_low 0.15129f
C5 VDPWR AMP 4.0862f
C6 charge_high share 0.31637f
C7 BIAS vout 5.64417f
C8 BIAS vref_high 0.67981f
C9 charge_high SAMPLE 0.74138f
C10 VDPWR charge_high 5.16047f
C11 L_BAR AMP 0.32572f
C12 RBMID TAIL 0.28059f
C13 HOLD TAIL 0.94092f
C14 RBMID vout 6.33235f
C15 L_BAR charge_high 0.24326f
C16 vref_low S_BAR 0.2005f
C17 RBMID vref_high 0.08621f
C18 HOLD vout 1.06652f
C19 share S_BAR 1.73094f
C20 HOLD vref_high 1.34791f
C21 BIAS RBMID 27.2898f
C22 S_BAR SAMPLE 0.90771f
C23 BIAS HOLD 17.648f
C24 VDPWR S_BAR 1.47885f
C25 vref_low share 0.31581f
C26 vref_low SAMPLE 15.6351f
C27 VDPWR vref_low 0.85134f
C28 share SAMPLE 1.11898f
C29 VDPWR share 1.70165f
C30 L_BAR S_BAR 14.0415f
C31 VDPWR SAMPLE 2.96114f
C32 HOLD RBMID 0.82066f
C33 charge_low TAIL 0.09588f
C34 H_BAR TAIL 0.26273f
C35 COMP TAIL 0.39101f
C36 L_BAR vref_low 0.56894f
C37 charge_low vout 0.34499f
C38 H_BAR vout 0.60159f
C39 charge_low vref_high 0.31955f
C40 vout COMP 88.206f
C41 H_BAR vref_high 0.55001f
C42 L_BAR share 0.18608f
C43 vref_high COMP 0.28757f
C44 MIRROR TAIL 14.7801f
C45 L_BAR SAMPLE 0.94254f
C46 BIAS charge_low 0.13759f
C47 BIAS H_BAR 0.44326f
C48 MIRROR vout 1.41213f
C49 BIAS COMP 0.61847f
C50 VDPWR L_BAR 1.47678f
C51 MIRROR vref_high 0.30573f
C52 BIAS MIRROR 0.32391f
C53 TAIL AMP 14.5619f
C54 vout AMP 5.59254f
C55 vref_high AMP 0.36079f
C56 charge_low RBMID 0.1591f
C57 H_BAR RBMID 0.0546f
C58 RBMID COMP 0.34126f
C59 charge_high TAIL 0.09588f
C60 HOLD charge_low 0.54663f
C61 BIAS AMP 0.81912f
C62 HOLD H_BAR 0.30556f
C63 HOLD COMP 0.82333f
C64 charge_high vout 0.34848f
C65 charge_high vref_high 0.71753f
C66 MIRROR RBMID 14.1735f
C67 MIRROR HOLD 0.36443f
C68 BIAS charge_high 0.11255f
C69 RBMID AMP 12.299f
C70 TAIL S_BAR 0.22804f
C71 HOLD AMP 1.5858f
C72 vout S_BAR 0.61292f
C73 vref_high S_BAR 14.0727f
C74 charge_high RBMID 0.09755f
C75 HOLD charge_high 0.13989f
C76 vref_low TAIL 0.22855f
C77 H_BAR charge_low 0.76108f
C78 charge_low COMP 0.12909f
C79 BIAS S_BAR 0.33222f
C80 H_BAR COMP 0.25511f
C81 share TAIL 0.09588f
C82 vref_low vout 1.80542f
C83 vref_low vref_high 15.0081f
C84 TAIL SAMPLE 0.2295f
C85 vout share 0.80799f
C86 MIRROR charge_low 0.09581f
C87 MIRROR H_BAR 0.35143f
C88 share vref_high 0.30393f
C89 MIRROR COMP 0.41072f
C90 VDPWR TAIL 4.03493f
C91 vout SAMPLE 1.30602f
C92 BIAS vref_low 1.01769f
C93 vref_high SAMPLE 1.77477f
C94 VDPWR vout 11.147f
C95 BIAS share 0.13127f
C96 VDPWR vref_high 0.86976f
C97 BIAS SAMPLE 1.22764f
C98 RBMID S_BAR 0.04231f
C99 BIAS VDPWR 7.37419f
C100 charge_low AMP 0.12231f
C101 L_BAR TAIL 0.22804f
C102 H_BAR AMP 0.33432f
C103 HOLD S_BAR 0.68861f
C104 COMP AMP 27.1138f
C105 L_BAR vout 0.5336f
C106 L_BAR vref_high 0.20135f
C107 RBMID vref_low 0.16036f
C108 MIRROR AMP 1.49262f
C109 charge_high charge_low 2.94145f
C110 H_BAR charge_high 1.84677f
C111 RBMID share 0.1328f
C112 charge_high COMP 0.12909f
C113 HOLD vref_low 0.81247f
C114 BIAS L_BAR 0.32031f
C115 HOLD share 0.81245f
C116 RBMID SAMPLE 0.62895f
C117 MIRROR charge_high 0.09581f
C118 VDPWR RBMID 2.26323f
C119 HOLD SAMPLE 7.73697f
C120 VDPWR HOLD 2.42188f
C121 L_BAR RBMID 0.04221f
C122 charge_high AMP 0.10627f
C123 charge_low S_BAR 0.251f
C124 H_BAR S_BAR 0.2516f
C125 HOLD L_BAR 0.35767f
C126 COMP S_BAR 0.25324f
C127 MIRROR S_BAR 0.30551f
C128 charge_low vref_low 0.78075f
C129 H_BAR vref_low 0.19024f
C130 vref_low COMP 0.28961f
C131 charge_low share 2.94123f
C132 H_BAR share 3.98516f
C133 share COMP 0.1946f
C134 charge_low SAMPLE 0.93022f
C135 H_BAR SAMPLE 0.87168f
C136 MIRROR vref_low 0.30593f
C137 COMP SAMPLE 1.30705f
C138 VDPWR charge_low 1.8988f
C139 VDPWR H_BAR 3.22917f
C140 VDPWR COMP 4.44695f
C141 MIRROR share 0.09581f
C142 AMP S_BAR 0.33692f
C143 MIRROR SAMPLE 0.31918f
C144 VDPWR MIRROR 1.83089f
C145 charge_high S_BAR 0.23469f
C146 vref_low AMP 0.66207f
C147 L_BAR charge_low 1.60091f
C148 H_BAR L_BAR 14.0577f
C149 vout TAIL 1.39738f
C150 L_BAR COMP 0.26653f
C151 share AMP 0.15041f
C152 vref_high TAIL 0.22843f
C153 vout VGND 93.83439f
C154 vref_low VGND 26.63809f
C155 vref_high VGND 26.42393f
C156 share VGND 8.25166f
C157 charge_low VGND 8.01006f
C158 charge_high VGND 7.94353f
C159 VDPWR VGND 79.15408f
C160 RBMID VGND 29.4595f
C161 MIRROR VGND 17.83198f
C162 AMP VGND 33.7281f
C163 TAIL VGND 13.95962f
C164 S_BAR VGND 12.03089f
C165 L_BAR VGND 11.18795f
C166 H_BAR VGND 32.63869f
C167 BIAS VGND 33.68814f
C168 BIAS.n0 VGND 10.5804f
C169 BIAS.n1 VGND 0.02353f
C170 BIAS.t2 VGND 0.69362f
C171 BIAS.n2 VGND 0.1789f
C172 BIAS.n3 VGND 0.01351f
C173 BIAS.n4 VGND 2.57341f
C174 BIAS.n5 VGND 0.04187f
C175 BIAS.n6 VGND 2.06517f
C176 BIAS.n7 VGND 0.01351f
C177 BIAS.n8 VGND 0.54529f
C178 BIAS.n9 VGND 0.04187f
C179 BIAS.n10 VGND 0.87405f
C180 BIAS.n11 VGND 0.01351f
C181 BIAS.n12 VGND 0.54529f
C182 BIAS.n13 VGND 0.04187f
C183 BIAS.n14 VGND 0.87405f
C184 BIAS.t0 VGND 0.15835f
C185 BIAS.n15 VGND 13.2621f
C186 BIAS.n16 VGND 19.6523f
C187 BIAS.n17 VGND 1.12324f
C188 H_BAR.n0 VGND 0.03622f
C189 H_BAR.t1 VGND 0.13574f
C190 H_BAR.n1 VGND 0.01174f
C191 H_BAR.t0 VGND 0.0592f
C192 H_BAR.n2 VGND 0.06392f
C193 H_BAR.n3 VGND 0.02024f
C194 H_BAR.n4 VGND 0.83991f
C195 H_BAR.n5 VGND 0.98939f
C196 H_BAR.n6 VGND 0.03566f
C197 L_BAR.n0 VGND 26.298f
C198 L_BAR.n1 VGND 0.04505f
C199 L_BAR.t1 VGND 0.15779f
C200 L_BAR.n2 VGND 0.0146f
C201 L_BAR.t0 VGND 0.06563f
C202 L_BAR.n3 VGND 0.07952f
C203 L_BAR.n4 VGND 0.02518f
C204 L_BAR.n5 VGND 1.11062f
C205 L_BAR.n6 VGND 1.29659f
C206 L_BAR.n7 VGND 0.04436f
C207 S_BAR.n0 VGND 25.7085f
C208 S_BAR.n1 VGND 0.04486f
C209 S_BAR.t1 VGND 0.15981f
C210 S_BAR.n2 VGND 0.01454f
C211 S_BAR.t0 VGND 0.068f
C212 S_BAR.n3 VGND 0.07917f
C213 S_BAR.n4 VGND 0.02507f
C214 S_BAR.n5 VGND 1.17154f
C215 S_BAR.n6 VGND 1.35671f
C216 S_BAR.n7 VGND 0.04416f
C217 SAMPLE.n0 VGND 0.08301f
C218 SAMPLE.n1 VGND 0.09161f
C219 SAMPLE.n2 VGND 0.35289f
C220 SAMPLE.t3 VGND 0.06207f
C221 SAMPLE.t2 VGND 0.13643f
C222 SAMPLE.n7 VGND 0.04028f
C223 SAMPLE.n8 VGND 0.11028f
C224 SAMPLE.n9 VGND 0.07881f
C225 SAMPLE.n10 VGND 0.11965f
C226 SAMPLE.n11 VGND 0.12835f
C227 SAMPLE.n12 VGND 0.08977f
C228 SAMPLE.n13 VGND 0.05677f
C229 SAMPLE.n14 VGND 0.09288f
C230 SAMPLE.n15 VGND 0.12835f
C231 SAMPLE.n16 VGND 0.08977f
C232 SAMPLE.n17 VGND 0.05677f
C233 SAMPLE.n18 VGND 0.06116f
C234 SAMPLE.n19 VGND 0.11028f
C235 SAMPLE.n20 VGND 0.07881f
C236 SAMPLE.n21 VGND 0.07582f
C237 SAMPLE.n22 VGND 0.06812f
C238 SAMPLE.n23 VGND 0.08293f
C239 SAMPLE.t4 VGND 0.05648f
C240 SAMPLE.n27 VGND 0.02341f
C241 SAMPLE.t1 VGND 0.1105f
C242 SAMPLE.n30 VGND 0.02745f
C243 SAMPLE.t5 VGND 0.05846f
C244 SAMPLE.n34 VGND 0.02341f
C245 SAMPLE.t0 VGND 0.13702f
C246 SAMPLE.n37 VGND 0.02745f
C247 SAMPLE.n38 VGND 0.02341f
C248 HOLD.n0 VGND 0.37372f
C249 HOLD.t1 VGND 0.06206f
C250 HOLD.n6 VGND 0.05276f
C251 HOLD.t0 VGND 0.13638f
C252 HOLD.n9 VGND 0.02887f
C253 HOLD.n10 VGND 0.12538f
C254 HOLD.n11 VGND 0.0875f
C255 HOLD.n12 VGND 0.10969f
C256 HOLD.n13 VGND 0.10771f
C257 HOLD.n14 VGND 0.068f
C258 HOLD.n15 VGND 0.07692f
C259 HOLD.n16 VGND 0.08217f
C260 HOLD.n17 VGND 0.10771f
C261 HOLD.n18 VGND 0.068f
C262 HOLD.n19 VGND 0.07692f
C263 HOLD.n20 VGND 0.04749f
C264 HOLD.n21 VGND 0.12538f
C265 HOLD.n22 VGND 0.0875f
C266 HOLD.n23 VGND 0.06479f
C267 HOLD.n24 VGND 0.06956f
C268 HOLD.n25 VGND 0.12088f
C269 HOLD.n26 VGND 0.02498f
C270 TAIL.n0 VGND 2.52157f
C271 TAIL.n1 VGND 0.01207f
C272 TAIL.t2 VGND 0.60132f
C273 TAIL.n2 VGND 0.03843f
C274 TAIL.t0 VGND 0.73087f
C275 TAIL.n3 VGND 0.2922f
C276 TAIL.n4 VGND 0.01207f
C277 TAIL.n5 VGND 2.02288f
C278 TAIL.n6 VGND 9.99226f
C279 TAIL.n7 VGND 13.6606f
C280 TAIL.n8 VGND 2.04639f
C281 TAIL.t1 VGND 0.1053f
C282 TAIL.n9 VGND 0.2922f
C283 TAIL.n10 VGND 0.03843f
C284 AMP.n1 VGND 0.02177f
C285 AMP.n2 VGND 1.35799f
C286 AMP.n3 VGND 0.02177f
C287 AMP.n4 VGND 1.57322f
C288 AMP.n5 VGND 0.02865f
C289 AMP.t1 VGND 0.89106f
C290 AMP.n6 VGND 0.22797f
C291 AMP.n8 VGND 1.57738f
C292 AMP.n9 VGND 7.57465f
C293 AMP.t2 VGND 0.19634f
C294 AMP.n10 VGND 16.2707f
C295 AMP.n11 VGND 27.1498f
C296 AMP.n12 VGND 4.87941f
C297 AMP.n13 VGND 1.60106f
C298 AMP.t0 VGND 0.08216f
C299 AMP.n14 VGND 0.22183f
C300 AMP.n15 VGND 0.02918f
C301 MIRROR.n0 VGND 18.5787f
C302 MIRROR.n2 VGND 0.01686f
C303 MIRROR.n3 VGND 0.68184f
C304 MIRROR.n4 VGND 0.05267f
C305 MIRROR.n5 VGND 1.57457f
C306 MIRROR.n6 VGND 0.01686f
C307 MIRROR.n7 VGND 0.68184f
C308 MIRROR.n8 VGND 0.05267f
C309 MIRROR.n9 VGND 1.22531f
C310 MIRROR.n10 VGND 0.02978f
C311 MIRROR.t1 VGND 0.89394f
C312 MIRROR.n11 VGND 0.23696f
C313 MIRROR.n13 VGND 1.54017f
C314 MIRROR.n14 VGND 1.56547f
C315 MIRROR.t2 VGND 0.32269f
C316 MIRROR.n15 VGND 0.23057f
C317 MIRROR.n16 VGND 0.03033f
C318 VGND.t4 VGND 0.4592p
C319 VGND.t6 VGND 0.45307p
C320 VGND.t53 VGND 0.03977f
C321 VGND.t13 VGND 0.81813f
C322 VGND.t11 VGND 0.81813f
C323 VGND.t1 VGND 1.90239f
C324 VGND.t46 VGND 0.04225f
C325 VGND.t49 VGND 0.03841f
C326 VDPWR.n0 VGND 1.34973f
C327 VDPWR.n1 VGND 1.29026f
C328 VDPWR.n2 VGND 32.8767f
C329 VDPWR.n3 VGND 1.00899f
C330 VDPWR.n4 VGND 0.98095f
C331 VDPWR.n5 VGND 2.51412f
C332 VDPWR.t13 VGND 0.07879f
C333 VDPWR.t12 VGND 0.04068f
C334 VDPWR.n10 VGND 0.1376f
C335 VDPWR.n17 VGND 0.09452f
C336 VDPWR.n28 VGND 0.1376f
C337 VDPWR.n49 VGND 0.09452f
C338 VDPWR.n52 VGND 0.10203f
C339 VDPWR.n53 VGND 1.18291f
C340 VDPWR.t16 VGND 0.07924f
C341 VDPWR.t15 VGND 0.04068f
C342 VDPWR.n58 VGND 0.1376f
C343 VDPWR.n65 VGND 0.09452f
C344 VDPWR.n76 VGND 0.1376f
C345 VDPWR.n97 VGND 0.09452f
C346 VDPWR.n100 VGND 0.10203f
C347 VDPWR.t11 VGND 0.08172f
C348 VDPWR.t10 VGND 0.04068f
C349 VDPWR.n105 VGND 0.1376f
C350 VDPWR.n112 VGND 0.09452f
C351 VDPWR.n123 VGND 0.1376f
C352 VDPWR.n144 VGND 0.09452f
C353 VDPWR.n147 VGND 0.10203f
C354 VDPWR.n153 VGND 0.04894f
C355 VDPWR.n154 VGND 0.08385f
C356 VDPWR.t1 VGND 0.02447f
C357 VDPWR.n162 VGND 0.04894f
C358 VDPWR.n163 VGND 0.03743f
C359 VDPWR.n167 VGND 0.08385f
C360 VDPWR.n175 VGND 0.07018f
C361 VDPWR.n181 VGND 0.04894f
C362 VDPWR.n188 VGND 0.03599f
C363 VDPWR.n194 VGND 0.07018f
C364 VDPWR.n198 VGND 0.10383f
C365 VDPWR.n199 VGND 0.66577f
C366 VDPWR.n205 VGND 0.04894f
C367 VDPWR.n206 VGND 0.08385f
C368 VDPWR.t0 VGND 0.02447f
C369 VDPWR.n214 VGND 0.04894f
C370 VDPWR.n215 VGND 0.03743f
C371 VDPWR.n219 VGND 0.08385f
C372 VDPWR.n227 VGND 0.07018f
C373 VDPWR.n233 VGND 0.04894f
C374 VDPWR.n240 VGND 0.03599f
C375 VDPWR.n246 VGND 0.07018f
C376 VDPWR.n250 VGND 0.10383f
C377 VDPWR.n251 VGND 0.66577f
C378 VDPWR.n257 VGND 0.04894f
C379 VDPWR.n258 VGND 0.08385f
C380 VDPWR.t2 VGND 0.02447f
C381 VDPWR.n266 VGND 0.04894f
C382 VDPWR.n267 VGND 0.03743f
C383 VDPWR.n271 VGND 0.08385f
C384 VDPWR.n279 VGND 0.07018f
C385 VDPWR.n285 VGND 0.04894f
C386 VDPWR.n292 VGND 0.03599f
C387 VDPWR.n298 VGND 0.07018f
C388 VDPWR.n302 VGND 0.10383f
C389 VDPWR.t8 VGND 0.73555f
C390 VDPWR.t7 VGND 0.06187f
C391 VDPWR.n307 VGND 0.12374f
C392 VDPWR.n312 VGND 0.12374f
C393 VDPWR.n316 VGND 0.19197f
C394 VDPWR.n348 VGND 0.1574f
C395 VDPWR.n354 VGND 0.0928f
C396 VDPWR.n355 VGND 0.12374f
C397 VDPWR.n397 VGND 0.19197f
C398 VDPWR.n398 VGND 0.1574f
C399 VDPWR.n399 VGND 0.12374f
C400 VDPWR.n405 VGND 0.0928f
C401 VDPWR.n408 VGND 0.10931f
C402 VDPWR.t6 VGND 0.73555f
C403 VDPWR.t5 VGND 0.06187f
C404 VDPWR.n413 VGND 0.12374f
C405 VDPWR.n418 VGND 0.12374f
C406 VDPWR.n422 VGND 0.19197f
C407 VDPWR.n454 VGND 0.1574f
C408 VDPWR.n460 VGND 0.0928f
C409 VDPWR.n461 VGND 0.12374f
C410 VDPWR.n503 VGND 0.19197f
C411 VDPWR.n504 VGND 0.1574f
C412 VDPWR.n505 VGND 0.12374f
C413 VDPWR.n511 VGND 0.0928f
C414 VDPWR.n514 VGND 0.10931f
C415 VDPWR.n518 VGND 0.1056f
C416 VDPWR.n521 VGND 0.06272f
C417 VDPWR.n528 VGND 0.06272f
C418 VDPWR.n532 VGND 0.04611f
C419 VDPWR.n536 VGND 0.06272f
C420 VDPWR.n540 VGND 0.06272f
C421 VDPWR.n544 VGND 0.06272f
C422 VDPWR.n548 VGND 0.1056f
C423 VDPWR.n561 VGND 0.08808f
C424 VDPWR.n567 VGND 0.06272f
C425 VDPWR.n573 VGND 0.06272f
C426 VDPWR.t9 VGND 0.03136f
C427 VDPWR.n579 VGND 0.04796f
C428 VDPWR.n585 VGND 0.06272f
C429 VDPWR.n592 VGND 0.06272f
C430 VDPWR.n599 VGND 0.08808f
C431 VDPWR.n605 VGND 0.11111f
C432 VDPWR.n609 VGND 0.1056f
C433 VDPWR.n612 VGND 0.06272f
C434 VDPWR.n619 VGND 0.06272f
C435 VDPWR.n623 VGND 0.04611f
C436 VDPWR.n627 VGND 0.06272f
C437 VDPWR.n631 VGND 0.06272f
C438 VDPWR.n635 VGND 0.06272f
C439 VDPWR.n639 VGND 0.1056f
C440 VDPWR.n652 VGND 0.08808f
C441 VDPWR.n658 VGND 0.06272f
C442 VDPWR.n664 VGND 0.06272f
C443 VDPWR.t14 VGND 0.03136f
C444 VDPWR.n670 VGND 0.04796f
C445 VDPWR.n676 VGND 0.06272f
C446 VDPWR.n683 VGND 0.06272f
C447 VDPWR.n690 VGND 0.08808f
C448 VDPWR.n696 VGND 0.11111f
C449 VDPWR.n697 VGND 0.83765f
C450 VDPWR.t4 VGND 3.75059f
C451 VDPWR.t3 VGND 0.27375f
C452 VDPWR.n702 VGND 0.54749f
C453 VDPWR.n707 VGND 0.54749f
C454 VDPWR.n711 VGND 0.84942f
C455 VDPWR.n887 VGND 0.69644f
C456 VDPWR.n893 VGND 0.41062f
C457 VDPWR.n894 VGND 0.54749f
C458 VDPWR.n1081 VGND 0.84942f
C459 VDPWR.n1082 VGND 0.69644f
C460 VDPWR.n1083 VGND 0.54749f
C461 VDPWR.n1089 VGND 0.41062f
C462 VDPWR.n1092 VGND 0.16409f
C463 charge_high.n0 VGND 10.2132f
C464 charge_low.n0 VGND 10.7108f
C465 share.n0 VGND 11.5054f
C466 vref_high.t0 VGND 0.30302f
C467 vref_high.t1 VGND 0.24145f
C468 vref_high.n0 VGND 30.4994f
C469 vref_low.t0 VGND 0.33095f
C470 vref_low.t1 VGND 0.25411f
C471 vref_low.n0 VGND 31.0343f
C472 vout.t0 VGND 2.28928f
C473 vout.t1 VGND 3.89344f
C474 vout.n0 VGND 7.46083f
C475 vout.n1 VGND 7.02102f
C476 vout.t2 VGND 0.12275p
C477 vout.n2 VGND 14.8043f
.ends
